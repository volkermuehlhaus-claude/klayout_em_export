* cascode_em_dc_ngspice: EM model with PDK devices for ngspice, generated by klayout_em_export tools/spice_wrapper.py
* pins: Cas_out = export port 1 (layout port 1), Cas_in = export port 2 (layout port 2), Cas_Bias = export port 15 (layout port 15)
* the EM model's equivalent circuit (snp2le):
.include cascode_em_dc_ngspice_le.cir
* PDK model libraries (ngspice):
* .lib <IHP-Open-PDK>/<ihp-sg13g2 or ihp-sg13cmos5l>/libs.tech/ngspice/models/cornerHBT.lib hbt_typ
* notes: rhigh_CDNS_785835985923@-28550,405: ideal resistor 13.003k (from its label; no temperature, no parasitics)
* notes: rhigh_CDNS_785835985924@-28550,6940: ideal resistor 2.997k (from its label; no temperature, no parasitics)
* notes: rsil_CDNS_785835985925@-26675,6090: ideal resistor 49.98 (from its label; no temperature, no parasitics)

.subckt cascode_em_dc_ngspice Cas_out Cas_in Cas_Bias
XEM Cas_out Cas_in n3 n4 n5 n6 n7 n8 n9 n10 n11 n12 n13 n14 Cas_Bias cascode_em_dc_ngspice_le
* npn13G2 npn13G2@-7230,590 (B port 3, C port 4, E port 5)
X1 n4 n3 n5 0 npn13G2 Nx=8 Ny=1 le=0.9u we=0.07u
* npn13G2 npn13G2@-7230,7700 (B port 10, C port 11, E port 12)
X2 n11 n10 n12 0 npn13G2 Nx=8 Ny=1 le=0.9u we=0.07u
* rhigh rhigh_CDNS_785835985923@-28550,405 (MINUS port 13, PLUS port 14)
*   static cell without parameters: ideal resistor from its label 'rhigh r=13.003k'
R3 n14 n13 13.003k
* rhigh rhigh_CDNS_785835985924@-28550,6940 (MINUS port 6, PLUS port 7)
*   static cell without parameters: ideal resistor from its label 'rhigh r=2.997k'
R4 n7 n6 2.997k
* rsil rsil_CDNS_785835985925@-26675,6090 (MINUS port 8, PLUS port 9)
*   static cell without parameters: ideal resistor from its label 'rsil r=49.98'
R5 n9 n8 49.98
* DC paths of the wiring (open at RF)
Ldc0_0 Cas_out n11 1m
Ldc1_0 0 n5 1m
Ldc1_1 n5 n14 1m
Ldc2_0 Cas_in n3 1m
Ldc3_0 n4 n12 1m
Ldc4_0 n6 Cas_Bias 1m
Ldc5_0 n7 n9 1m
Ldc5_1 n9 n13 1m
Ldc6_0 n8 n10 1m
.ends cascode_em_dc_ngspice
