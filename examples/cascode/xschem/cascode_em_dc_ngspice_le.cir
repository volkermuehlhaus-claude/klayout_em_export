* cascode_em_dc_ngspice_le - lumped-element equivalent (Ngspice / SPICE3)
* generated by snp2le 0.2.2
* EQUIVALENT CIRCUIT FOR VECTOR FITTED S-MATRIX
* Created using scikit-rf vectorFitting.py
*
*
* thermal noise of the passive: kT(I - S S^H) at the ports, from a spectral factor of this fit
* sources Rnz_e1..Rnz_e15 (0.25 ohm, the only noisy elements), 90 states nz_x*, controlled sources Gnz_*
* DC pin: Y = Y_fit + dY / (1 + s/wc), fc = 160 Hz, so the model meets the file's 0 Hz point. Nodes dcp_d*, controlled sources Gdcp_*, noiseless
.SUBCKT cascode_em_dc_ngspice_le p1 p2 p3 p4 p5 p6 p7 p8 p9 p10 p11 p12 p13 p14 p15
V1 p1 s1 0.0
R1 s1 0 50.0 noisy=0
Gd1_1 0 s1 p1 0 0.006323319062877414
Fd1_1 0 s1 V1 0.3161659531438707
Gr1_1_1 0 s1 x1_a1 0 -1.5275401831557929
Gr2_1_1 0 s1 x2_a1 0 1.5380036206930403
Gr3_re_1_1 0 s1 x3_re_a1 0 69697.5427438121
Gr3_im_1_1 0 s1 x3_im_a1 0 -4949.583896172971
Gr4_1_1 0 s1 x4_a1 0 0.32031316733042564
Gr5_1_1 0 s1 x5_a1 0 -0.23056891925865172
Gd1_2 0 s1 p2 0 -0.0005529222192318066
Fd1_2 0 s1 V2 -0.027646110961590333
Gr1_1_2 0 s1 x1_a2 0 0.02489451947605905
Gr2_1_2 0 s1 x2_a2 0 -0.006081200956065716
Gr3_re_1_2 0 s1 x3_re_a2 0 7134.872194598208
Gr3_im_1_2 0 s1 x3_im_a2 0 -2694.1450329168993
Gr4_1_2 0 s1 x4_a2 0 0.15882342820592343
Gr5_1_2 0 s1 x5_a2 0 0.0938229602536906
Gd1_3 0 s1 p3 0 0.0005442623702019845
Fd1_3 0 s1 V3 0.027213118510099225
Gr1_1_3 0 s1 x1_a3 0 -0.03331615118337429
Gr2_1_3 0 s1 x2_a3 0 -0.038427891824422314
Gr3_re_1_3 0 s1 x3_re_a3 0 2311.243513049013
Gr3_im_1_3 0 s1 x3_im_a3 0 2136.8243419824207
Gr4_1_3 0 s1 x4_a3 0 -0.1574809613901016
Gr5_1_3 0 s1 x5_a3 0 -0.06790183161990283
Gd1_4 0 s1 p4 0 -0.001211007263579837
Fd1_4 0 s1 V4 -0.06055036317899185
Gr1_1_4 0 s1 x1_a4 0 0.011170992885813844
Gr2_1_4 0 s1 x2_a4 0 0.17325923006784794
Gr3_re_1_4 0 s1 x3_re_a4 0 10001.450219616125
Gr3_im_1_4 0 s1 x3_im_a4 0 -4924.322816359589
Gr4_1_4 0 s1 x4_a4 0 0.27440865722901436
Gr5_1_4 0 s1 x5_a4 0 0.12442262865036005
Gd1_5 0 s1 p5 0 0.0015920238532778413
Fd1_5 0 s1 V5 0.07960119266389207
Gr1_1_5 0 s1 x1_a5 0 -0.135390657036905
Gr2_1_5 0 s1 x2_a5 0 -0.05360543264017285
Gr3_re_1_5 0 s1 x3_re_a5 0 -6147.902930818551
Gr3_im_1_5 0 s1 x3_im_a5 0 2046.368476323621
Gr4_1_5 0 s1 x4_a5 0 -0.22285965835523242
Gr5_1_5 0 s1 x5_a5 0 -0.11275938453193272
Gd1_6 0 s1 p6 0 -9.474267918843594e-06
Fd1_6 0 s1 V6 -0.00047371339594217977
Gr1_1_6 0 s1 x1_a6 0 0.000501560722373118
Gr2_1_6 0 s1 x2_a6 0 -0.002997563500930913
Gr3_re_1_6 0 s1 x3_re_a6 0 1822.6797592217229
Gr3_im_1_6 0 s1 x3_im_a6 0 -2184.5822242983063
Gr4_1_6 0 s1 x4_a6 0 -0.21668966364736242
Gr5_1_6 0 s1 x5_a6 0 0.004364139200276921
Gd1_7 0 s1 p7 0 1.142399461081516e-05
Fd1_7 0 s1 V7 0.000571199730540758
Gr1_1_7 0 s1 x1_a7 0 -0.006393834447456518
Gr2_1_7 0 s1 x2_a7 0 0.013798240835319428
Gr3_re_1_7 0 s1 x3_re_a7 0 -1632.3953723969198
Gr3_im_1_7 0 s1 x3_im_a7 0 2122.9877207623913
Gr4_1_7 0 s1 x4_a7 0 0.21671101127420944
Gr5_1_7 0 s1 x5_a7 0 -0.004794015416925753
Gd1_8 0 s1 p8 0 -7.914050842821596e-05
Fd1_8 0 s1 V8 -0.003957025421410798
Gr1_1_8 0 s1 x1_a8 0 -0.006835793865504254
Gr2_1_8 0 s1 x2_a8 0 0.02314803533664174
Gr3_re_1_8 0 s1 x3_re_a8 0 -1943.4905580710824
Gr3_im_1_8 0 s1 x3_im_a8 0 2562.5591479729624
Gr4_1_8 0 s1 x4_a8 0 0.3350232672306808
Gr5_1_8 0 s1 x5_a8 0 -0.0039663611935959265
Gd1_9 0 s1 p9 0 6.511730455392457e-05
Fd1_9 0 s1 V9 0.0032558652276962288
Gr1_1_9 0 s1 x1_a9 0 0.006717190878704011
Gr2_1_9 0 s1 x2_a9 0 -0.0211870516777954
Gr3_re_1_9 0 s1 x3_re_a9 0 2053.359661151789
Gr3_im_1_9 0 s1 x3_im_a9 0 -3017.0657924465345
Gr4_1_9 0 s1 x4_a9 0 -0.3353784543847857
Gr5_1_9 0 s1 x5_a9 0 0.005809302746100857
Gd1_10 0 s1 p10 0 0.004194373028306643
Fd1_10 0 s1 V10 0.20971865141533214
Gr1_1_10 0 s1 x1_a10 0 -0.11572644873538628
Gr2_1_10 0 s1 x2_a10 0 -0.7623934827991812
Gr3_re_1_10 0 s1 x3_re_a10 0 -32119.370113657933
Gr3_im_1_10 0 s1 x3_im_a10 0 14626.573391662318
Gr4_1_10 0 s1 x4_a10 0 0.4261493052082127
Gr5_1_10 0 s1 x5_a10 0 -0.09116785888806417
Gd1_11 0 s1 p11 0 -0.00611550602685029
Fd1_11 0 s1 V11 -0.3057753013425145
Gr1_1_11 0 s1 x1_a11 0 0.2882226737824528
Gr2_1_11 0 s1 x2_a11 0 0.9229972884591056
Gr3_re_1_11 0 s1 x3_re_a11 0 45544.701072290765
Gr3_im_1_11 0 s1 x3_im_a11 0 -26286.96387493422
Gr4_1_11 0 s1 x4_a11 0 -0.318390050844766
Gr5_1_11 0 s1 x5_a11 0 -0.12185232860058237
Gd1_12 0 s1 p12 0 0.0025232675047802315
Fd1_12 0 s1 V12 0.12616337523901158
Gr1_1_12 0 s1 x1_a12 0 -0.10386850271944639
Gr2_1_12 0 s1 x2_a12 0 -0.5808289872830257
Gr3_re_1_12 0 s1 x3_re_a12 0 -15567.558411152691
Gr3_im_1_12 0 s1 x3_im_a12 0 6210.735807843168
Gr4_1_12 0 s1 x4_a12 0 -0.2860847704916561
Gr5_1_12 0 s1 x5_a12 0 0.1393995567195167
Gd1_13 0 s1 p13 0 -8.440561473171471e-05
Fd1_13 0 s1 V13 -0.004220280736585736
Gr1_1_13 0 s1 x1_a13 0 0.0006847821527268436
Gr2_1_13 0 s1 x2_a13 0 0.010477783743856814
Gr3_re_1_13 0 s1 x3_re_a13 0 -1301.4339840643786
Gr3_im_1_13 0 s1 x3_im_a13 0 2210.486321512793
Gr4_1_13 0 s1 x4_a13 0 0.256173480033085
Gr5_1_13 0 s1 x5_a13 0 -0.0032437690708255053
Gd1_14 0 s1 p14 0 0.00012842564072413796
Fd1_14 0 s1 V14 0.006421282036206898
Gr1_1_14 0 s1 x1_a14 0 -0.014800756855306092
Gr2_1_14 0 s1 x2_a14 0 0.01060709186701282
Gr3_re_1_14 0 s1 x3_re_a14 0 1713.2791066003526
Gr3_im_1_14 0 s1 x3_im_a14 0 -2177.789420855332
Gr4_1_14 0 s1 x4_a14 0 -0.2561864645175798
Gr5_1_14 0 s1 x5_a14 0 0.0004477120102476718
Gd1_15 0 s1 p15 0 1.8814078249983353e-05
Fd1_15 0 s1 V15 0.0009407039124991677
Gr1_1_15 0 s1 x1_a15 0 0.004317808418291086
Gr2_1_15 0 s1 x2_a15 0 -0.006908841795885835
Gr3_re_1_15 0 s1 x3_re_a15 0 -1931.019077870791
Gr3_im_1_15 0 s1 x3_im_a15 0 2107.1049559607827
Gr4_1_15 0 s1 x4_a15 0 0.21650397007122174
Gr5_1_15 0 s1 x5_a15 0 -0.00364164227367579
Cx1_a1 x1_a1 0 1.5871725736917026e-13
Gx1_a1 0 x1_a1 p1 0 0.03055080366311586
Fx1_a1 0 x1_a1 V1 1.527540183155793
Rp1_a1 0 x1_a1 1.0 noisy=0
Cx2_a1 x2_a1 0 3.688153046977837e-13
Gx2_a1 0 x2_a1 p1 0 0.030760072413860806
Fx2_a1 0 x2_a1 V1 1.5380036206930405
Rp2_a1 0 x2_a1 1.0 noisy=0
Cx3_re_a1 x3_re_a1 0 2.3135888003926714e-12
Gx3_re_a1 0 x3_re_a1 p1 0 4.48151366049877e-09
Fx3_re_a1 0 x3_re_a1 V1 2.2407568302493852e-07
Rp3_re_re_a1 0 x3_re_a1 1.0 noisy=0
Gp3_re_im_a1 0 x3_re_a1 x3_im_a1 0 2.9111243944429863
Cx3_im_a1 x3_im_a1 0 2.3135888003926714e-12
Gp3_im_re_a1 0 x3_im_a1 x3_re_a1 0 -2.9111243944429863
Rp3_im_im_a1 0 x3_im_a1 1.0 noisy=0
Cx4_a1 x4_a1 0 1.3081951314894418e-11
Gx4_a1 0 x4_a1 p1 0 0.011384220065197945
Fx4_a1 0 x4_a1 V1 0.5692110032598973
Rp4_a1 0 x4_a1 1.0 noisy=0
Cx5_a1 x5_a1 0 8.108684533816161e-13
Gx5_a1 0 x5_a1 p1 0 0.006428671511318401
Fx5_a1 0 x5_a1 V1 0.3214335755659201
Rp5_a1 0 x5_a1 1.0 noisy=0
V2 p2 s2 0.0
R2 s2 0 50.0 noisy=0
Gd2_1 0 s2 p1 0 -0.000552930319729318
Fd2_1 0 s2 V1 -0.0276465159864659
Gr1_2_1 0 s2 x1_a1 0 0.028535000228249934
Gr2_2_1 0 s2 x2_a1 0 -0.005971028785252176
Gr3_re_2_1 0 s2 x3_re_a1 0 7514.597437121709
Gr3_im_2_1 0 s2 x3_im_a1 0 -2837.8075187657682
Gr4_2_1 0 s2 x4_a1 0 0.07782717131042535
Gr5_2_1 0 s2 x5_a1 0 0.1899422083283194
Gd2_2 0 s2 p2 0 0.012719211543332547
Fd2_2 0 s2 V2 0.6359605771666273
Gr1_2_2 0 s2 x1_a2 0 -1.7508808709397987
Gr2_2_2 0 s2 x2_a2 0 1.5100120516333284
Gr3_re_2_2 0 s2 x3_re_a2 0 -49897.18515051176
Gr3_im_2_2 0 s2 x3_im_a2 0 -3154.0584975794204
Gr4_2_2 0 s2 x4_a2 0 0.0339499221698356
Gr5_2_2 0 s2 x5_a2 0 0.650732532917313
Gd2_3 0 s2 p3 0 -0.0013749894299845086
Fd2_3 0 s2 V3 -0.06874947149922543
Gr1_2_3 0 s2 x1_a3 0 -0.42599573372117977
Gr2_2_3 0 s2 x2_a3 0 1.0830667686682514
Gr3_re_2_3 0 s2 x3_re_a3 0 -36351.48607661324
Gr3_im_2_3 0 s2 x3_im_a3 0 -36792.171536423055
Gr4_2_3 0 s2 x4_a3 0 -0.037139421861090725
Gr5_2_3 0 s2 x5_a3 0 0.13180888733396132
Gd2_4 0 s2 p4 0 -0.0004548014578138692
Fd2_4 0 s2 V4 -0.02274007289069346
Gr1_2_4 0 s2 x1_a4 0 0.39422708011045887
Gr2_2_4 0 s2 x2_a4 0 -0.9403627750240374
Gr3_re_2_4 0 s2 x3_re_a4 0 39141.044601794245
Gr3_im_2_4 0 s2 x3_im_a4 0 5588.454176152122
Gr4_2_4 0 s2 x4_a4 0 0.06573166480778339
Gr5_2_4 0 s2 x5_a4 0 0.4418827587251547
Gd2_5 0 s2 p5 0 0.0027219164364814465
Fd2_5 0 s2 V5 0.13609582182407232
Gr1_2_5 0 s2 x1_a5 0 0.0014385948210126483
Gr2_2_5 0 s2 x2_a5 0 -0.5360182489181338
Gr3_re_2_5 0 s2 x3_re_a5 0 18580.68280484885
Gr3_im_2_5 0 s2 x3_im_a5 0 40364.130121187074
Gr4_2_5 0 s2 x4_a5 0 -0.05529392414078149
Gr5_2_5 0 s2 x5_a5 0 -0.5734735124914069
Gd2_6 0 s2 p6 0 4.0237747681967765e-05
Fd2_6 0 s2 V6 0.0020118873840983885
Gr1_2_6 0 s2 x1_a6 0 -0.007610238229243672
Gr2_2_6 0 s2 x2_a6 0 0.007321906866735432
Gr3_re_2_6 0 s2 x3_re_a6 0 133.8578338094832
Gr3_im_2_6 0 s2 x3_im_a6 0 -641.9086745302377
Gr4_2_6 0 s2 x4_a6 0 -0.05218779908837469
Gr5_2_6 0 s2 x5_a6 0 -0.007980813324165658
Gd2_7 0 s2 p7 0 -1.6120666815092876e-05
Fd2_7 0 s2 V7 -0.000806033340754644
Gr1_2_7 0 s2 x1_a7 0 -0.00022212988963383652
Gr2_2_7 0 s2 x2_a7 0 0.0006887460501689717
Gr3_re_2_7 0 s2 x3_re_a7 0 -53.43558741520189
Gr3_im_2_7 0 s2 x3_im_a7 0 566.9619260552354
Gr4_2_7 0 s2 x4_a7 0 0.05221628655512075
Gr5_2_7 0 s2 x5_a7 0 0.01144093094450274
Gd2_8 0 s2 p8 0 5.480762298785988e-05
Fd2_8 0 s2 V8 0.002740381149392994
Gr1_2_8 0 s2 x1_a8 0 -0.010195930975277868
Gr2_2_8 0 s2 x2_a8 0 0.007325289015941217
Gr3_re_2_8 0 s2 x3_re_a8 0 -323.93797117940414
Gr3_im_2_8 0 s2 x3_im_a8 0 968.5457546626418
Gr4_2_8 0 s2 x4_a8 0 0.08074319754027119
Gr5_2_8 0 s2 x5_a8 0 0.01864311943950522
Gd2_9 0 s2 p9 0 -2.4520605625149693e-05
Fd2_9 0 s2 V9 -0.0012260302812574847
Gr1_2_9 0 s2 x1_a9 0 0.004227221926333871
Gr2_2_9 0 s2 x2_a9 0 -0.0012407563634305183
Gr3_re_2_9 0 s2 x3_re_a9 0 411.5342527207068
Gr3_im_2_9 0 s2 x3_im_a9 0 -1019.4709365373773
Gr4_2_9 0 s2 x4_a9 0 -0.08078912098077463
Gr5_2_9 0 s2 x5_a9 0 -0.017917332453280452
Gd2_10 0 s2 p10 0 0.0005955487837653063
Fd2_10 0 s2 V10 0.02977743918826532
Gr1_2_10 0 s2 x1_a10 0 -0.10055526569689266
Gr2_2_10 0 s2 x2_a10 0 0.24184564294680302
Gr3_re_2_10 0 s2 x3_re_a10 0 -16928.919248935996
Gr3_im_2_10 0 s2 x3_im_a10 0 -15423.883276202172
Gr4_2_10 0 s2 x4_a10 0 0.10232818253226608
Gr5_2_10 0 s2 x5_a10 0 -0.4208077183035725
Gd2_11 0 s2 p11 0 0.00018482276342616794
Fd2_11 0 s2 V11 0.009241138171308397
Gr1_2_11 0 s2 x1_a11 0 -0.09073598275493237
Gr2_2_11 0 s2 x2_a11 0 0.24702771930736178
Gr3_re_2_11 0 s2 x3_re_a11 0 -2576.8172328790206
Gr3_im_2_11 0 s2 x3_im_a11 0 3155.371519071014
Gr4_2_11 0 s2 x4_a11 0 -0.07773341980048606
Gr5_2_11 0 s2 x5_a11 0 -0.42045442553864765
Gd2_12 0 s2 p12 0 -0.00019868381859253242
Fd2_12 0 s2 V12 -0.009934190929626621
Gr1_2_12 0 s2 x1_a12 0 0.058015335237894816
Gr2_2_12 0 s2 x2_a12 0 -0.4233348238061445
Gr3_re_2_12 0 s2 x3_re_a12 0 21455.23333076672
Gr3_im_2_12 0 s2 x3_im_a12 0 580.160377916264
Gr4_2_12 0 s2 x4_a12 0 -0.06729723830352702
Gr5_2_12 0 s2 x5_a12 0 0.5473327601803324
Gd2_13 0 s2 p13 0 3.2072671821703195e-05
Fd2_13 0 s2 V13 0.0016036335910851597
Gr1_2_13 0 s2 x1_a13 0 -0.0023464767079430507
Gr2_2_13 0 s2 x2_a13 0 -0.0010305936148511331
Gr3_re_2_13 0 s2 x3_re_a13 0 -463.7422954257318
Gr3_im_2_13 0 s2 x3_im_a13 0 855.9374846490692
Gr4_2_13 0 s2 x4_a13 0 0.06169333519753284
Gr5_2_13 0 s2 x5_a13 0 0.012800963070771467
Gd2_14 0 s2 p14 0 -1.2513645525766264e-05
Fd2_14 0 s2 V14 -0.0006256822762883132
Gr1_2_14 0 s2 x1_a14 0 -0.005645632384929924
Gr2_2_14 0 s2 x2_a14 0 0.010662525185724471
Gr3_re_2_14 0 s2 x3_re_a14 0 446.9804506379126
Gr3_im_2_14 0 s2 x3_im_a14 0 -924.3244552450093
Gr4_2_14 0 s2 x4_a14 0 -0.06166952639336618
Gr5_2_14 0 s2 x5_a14 0 -0.006595047740009898
Gd2_15 0 s2 p15 0 -6.174996269028674e-05
Fd2_15 0 s2 V15 -0.0030874981345143365
Gr1_2_15 0 s2 x1_a15 0 0.012607668567282983
Gr2_2_15 0 s2 x2_a15 0 -0.014685685657151972
Gr3_re_2_15 0 s2 x3_re_a15 0 -210.33666959477884
Gr3_im_2_15 0 s2 x3_im_a15 0 617.0245728579027
Gr4_2_15 0 s2 x4_a15 0 0.052130673875737214
Gr5_2_15 0 s2 x5_a15 0 0.005364470475068663
Cx1_a2 x1_a2 0 1.5871725736917026e-13
Gx1_a2 0 x1_a2 p2 0 0.03501761741879597
Fx1_a2 0 x1_a2 V2 1.7508808709397987
Rp1_a2 0 x1_a2 1.0 noisy=0
Cx2_a2 x2_a2 0 3.688153046977837e-13
Gx2_a2 0 x2_a2 p2 0 0.03020024103266657
Fx2_a2 0 x2_a2 V2 1.5100120516333286
Rp2_a2 0 x2_a2 1.0 noisy=0
Cx3_re_a2 x3_re_a2 0 2.3135888003926714e-12
Gx3_re_a2 0 x3_re_a2 p2 0 4.720113079011175e-09
Fx3_re_a2 0 x3_re_a2 V2 2.3600565395055876e-07
Rp3_re_re_a2 0 x3_re_a2 1.0 noisy=0
Gp3_re_im_a2 0 x3_re_a2 x3_im_a2 0 2.9111243944429863
Cx3_im_a2 x3_im_a2 0 2.3135888003926714e-12
Gp3_im_re_a2 0 x3_im_a2 x3_re_a2 0 -2.9111243944429863
Rp3_im_im_a2 0 x3_im_a2 1.0 noisy=0
Cx4_a2 x4_a2 0 1.3081951314894418e-11
Gx4_a2 0 x4_a2 p2 0 0.0055785332710804785
Fx4_a2 0 x4_a2 V2 0.27892666355402396
Rp4_a2 0 x4_a2 1.0 noisy=0
Cx5_a2 x5_a2 0 8.108684533816161e-13
Gx5_a2 0 x5_a2 p2 0 0.013014650658346262
Fx5_a2 0 x5_a2 V2 0.6507325329173131
Rp5_a2 0 x5_a2 1.0 noisy=0
V3 p3 s3 0.0
R3 s3 0 50.0 noisy=0
Gd3_1 0 s3 p1 0 0.0005442767179615751
Fd3_1 0 s3 V1 0.027213835898078752
Gr1_3_1 0 s3 x1_a1 0 -0.021508891704740945
Gr2_3_1 0 s3 x2_a1 0 -0.027060082412793188
Gr3_re_3_1 0 s3 x3_re_a1 0 2339.021729366257
Gr3_im_3_1 0 s3 x3_im_a1 0 2162.7788413750864
Gr4_3_1 0 s3 x4_a1 0 -0.07719476480030353
Gr5_3_1 0 s3 x5_a1 0 -0.06603345732436096
Gd3_2 0 s3 p2 0 -0.0013749654414059603
Fd3_2 0 s3 V2 -0.06874827207029802
Gr1_3_2 0 s3 x1_a2 0 -0.23992918866358234
Gr2_3_2 0 s3 x2_a2 0 0.7768391083608602
Gr3_re_3_2 0 s3 x3_re_a2 0 -34924.078587215365
Gr3_im_3_2 0 s3 x3_im_a2 0 -35346.62436270975
Gr4_3_2 0 s3 x4_a2 0 -0.03715162103958257
Gr5_3_2 0 s3 x5_a2 0 0.06331461149918192
Gd3_3 0 s3 p3 0 -0.015763691156896867
Fd3_3 0 s3 V3 -0.7881845578448433
Gr1_3_3 0 s3 x1_a3 0 0.4122108143065749
Gr2_3_3 0 s3 x2_a3 0 0.5440840856827439
Gr3_re_3_3 0 s3 x3_re_a3 0 -44246.61486711374
Gr3_im_3_3 0 s3 x3_im_a3 0 -32641.255398696787
Gr4_3_3 0 s3 x4_a3 0 0.031022449573619597
Gr5_3_3 0 s3 x5_a3 0 0.20776239924910506
Gd3_4 0 s3 p4 0 -0.0008486608198042398
Fd3_4 0 s3 V4 -0.042433040990211994
Gr1_3_4 0 s3 x1_a4 0 0.9861229460027608
Gr2_3_4 0 s3 x2_a4 0 -0.6764272297149254
Gr3_re_3_4 0 s3 x3_re_a4 0 345.4724636296677
Gr3_im_3_4 0 s3 x3_im_a4 0 27936.360801516723
Gr4_3_4 0 s3 x4_a4 0 -0.06374781195315561
Gr5_3_4 0 s3 x5_a4 0 -0.13383904460604812
Gd3_5 0 s3 p5 0 0.0025636899665764158
Fd3_5 0 s3 V5 0.12818449832882078
Gr1_3_5 0 s3 x1_a5 0 0.7246154044214215
Gr2_3_5 0 s3 x2_a5 0 -0.4550859509436912
Gr3_re_3_5 0 s3 x3_re_a5 0 24961.59124222953
Gr3_im_3_5 0 s3 x3_im_a5 0 32883.65616228651
Gr4_3_5 0 s3 x4_a5 0 0.05767910921348673
Gr5_3_5 0 s3 x5_a5 0 0.06143828005840236
Gd3_6 0 s3 p6 0 -4.049384842693921e-05
Fd3_6 0 s3 V6 -0.0020246924213469606
Gr1_3_6 0 s3 x1_a6 0 0.006213661029700015
Gr2_3_6 0 s3 x2_a6 0 -0.003260412824155072
Gr3_re_3_6 0 s3 x3_re_a6 0 -420.4068174075851
Gr3_im_3_6 0 s3 x3_im_a6 0 28.27483290398507
Gr4_3_6 0 s3 x4_a6 0 0.051884868604150015
Gr5_3_6 0 s3 x5_a6 0 0.0037224561411567164
Gd3_7 0 s3 p7 0 5.975547237307722e-05
Fd3_7 0 s3 V7 0.0029877736186538608
Gr1_3_7 0 s3 x1_a7 0 -0.007241344015070974
Gr2_3_7 0 s3 x2_a7 0 0.004202827449023361
Gr3_re_3_7 0 s3 x3_re_a7 0 359.10142287363107
Gr3_im_3_7 0 s3 x3_im_a7 0 -130.79782150310092
Gr4_3_7 0 s3 x4_a7 0 -0.05189288769011073
Gr5_3_7 0 s3 x5_a7 0 -0.0032359212967588637
Gd3_8 0 s3 p8 0 0.00011291346602924465
Fd3_8 0 s3 V8 0.005645673301462233
Gr1_3_8 0 s3 x1_a8 0 -0.01437983771359687
Gr2_3_8 0 s3 x2_a8 0 0.007024126086308491
Gr3_re_3_8 0 s3 x3_re_a8 0 725.8843131012792
Gr3_im_3_8 0 s3 x3_im_a8 0 -464.1622574943525
Gr4_3_8 0 s3 x4_a8 0 -0.0801694430018385
Gr5_3_8 0 s3 x5_a8 0 -0.0028551145728657446
Gd3_9 0 s3 p9 0 -8.15675819425805e-05
Fd3_9 0 s3 V9 -0.0040783790971290245
Gr1_3_9 0 s3 x1_a9 0 0.009386657863294293
Gr2_3_9 0 s3 x2_a9 0 -0.0020619099927014087
Gr3_re_3_9 0 s3 x3_re_a9 0 -661.8524961188374
Gr3_im_3_9 0 s3 x3_im_a9 0 684.4631498193321
Gr4_3_9 0 s3 x4_a9 0 0.08028566496260704
Gr5_3_9 0 s3 x5_a9 0 0.0010921069907463162
Gd3_10 0 s3 p10 0 -0.0006981334580006158
Fd3_10 0 s3 V10 -0.03490667290003079
Gr1_3_10 0 s3 x1_a10 0 0.03251493198881739
Gr2_3_10 0 s3 x2_a10 0 0.08231885697742165
Gr3_re_3_10 0 s3 x3_re_a10 0 -7460.983056635973
Gr3_im_3_10 0 s3 x3_im_a10 0 -28162.144826762134
Gr4_3_10 0 s3 x4_a10 0 -0.10239561302135304
Gr5_3_10 0 s3 x5_a10 0 0.1168703211130736
Gd3_11 0 s3 p11 0 0.00020667992214587036
Fd3_11 0 s3 V11 0.01033399610729352
Gr1_3_11 0 s3 x1_a11 0 -0.06164031002233922
Gr2_3_11 0 s3 x2_a11 0 0.06307070251501128
Gr3_re_3_11 0 s3 x3_re_a11 0 422.3557326492377
Gr3_im_3_11 0 s3 x3_im_a11 0 -7398.482256845919
Gr4_3_11 0 s3 x4_a11 0 0.07705755303581693
Gr5_3_11 0 s3 x5_a11 0 0.09357795495269698
Gd3_12 0 s3 p12 0 0.00117889137740001
Fd3_12 0 s3 V12 0.0589445688700005
Gr1_3_12 0 s3 x1_a12 0 -0.12818265829643885
Gr2_3_12 0 s3 x2_a12 0 -0.09937912777586423
Gr3_re_3_12 0 s3 x3_re_a12 0 7825.618633411246
Gr3_im_3_12 0 s3 x3_im_a12 0 26538.718228947077
Gr4_3_12 0 s3 x4_a12 0 0.06726899790047788
Gr5_3_12 0 s3 x5_a12 0 -0.12511428931996119
Gd3_13 0 s3 p13 0 1.5788793751188795e-05
Fd3_13 0 s3 V13 0.0007894396875594399
Gr1_3_13 0 s3 x1_a13 0 -0.001917996225067253
Gr2_3_13 0 s3 x2_a13 0 -0.0022148991058665657
Gr3_re_3_13 0 s3 x3_re_a13 0 550.6500285028468
Gr3_im_3_13 0 s3 x3_im_a13 0 -804.3733169372036
Gr4_3_13 0 s3 x4_a13 0 -0.061313899698284054
Gr5_3_13 0 s3 x5_a13 0 0.0014913714448890458
Gd3_14 0 s3 p14 0 3.209373124573447e-05
Fd3_14 0 s3 V14 0.0016046865622867236
Gr1_3_14 0 s3 x1_a14 0 -0.003073286484698408
Gr2_3_14 0 s3 x2_a14 0 0.005482686887890901
Gr3_re_3_14 0 s3 x3_re_a14 0 -592.179898189421
Gr3_im_3_14 0 s3 x3_im_a14 0 609.7882565245384
Gr4_3_14 0 s3 x4_a14 0 0.06131129242762518
Gr5_3_14 0 s3 x5_a14 0 -0.0008891934123334742
Gd3_15 0 s3 p15 0 2.7715700081860032e-05
Fd3_15 0 s3 V15 0.0013857850040930016
Gr1_3_15 0 s3 x1_a15 0 -0.004116580085876202
Gr2_3_15 0 s3 x2_a15 0 0.002834968854834245
Gr3_re_3_15 0 s3 x3_re_a15 0 566.022774540546
Gr3_im_3_15 0 s3 x3_im_a15 0 54.44043060459136
Gr4_3_15 0 s3 x4_a15 0 -0.05183421135088582
Gr5_3_15 0 s3 x5_a15 0 -0.004010382082265207
Cx1_a3 x1_a3 0 1.5871725736917026e-13
Gx1_a3 0 x1_a3 p3 0 0.01972245603064121
Fx1_a3 0 x1_a3 V3 0.9861228015320606
Rp1_a3 0 x1_a3 1.0 noisy=0
Cx2_a3 x2_a3 0 3.688153046977837e-13
Gx2_a3 0 x2_a3 p3 0 0.021661335373365034
Fx2_a3 0 x2_a3 V3 1.0830667686682518
Rp2_a3 0 x2_a3 1.0 noisy=0
Cx3_re_a3 x3_re_a3 0 2.3135888003926714e-12
Gx3_re_a3 0 x3_re_a3 p3 0 4.534800056141636e-09
Fx3_re_a3 0 x3_re_a3 V3 2.267400028070818e-07
Rp3_re_re_a3 0 x3_re_a3 1.0 noisy=0
Gp3_re_im_a3 0 x3_re_a3 x3_im_a3 0 2.9111243944429863
Cx3_im_a3 x3_im_a3 0 2.3135888003926714e-12
Gp3_im_re_a3 0 x3_im_a3 x3_re_a3 0 -2.9111243944429863
Rp3_im_im_a3 0 x3_im_a3 1.0 noisy=0
Cx4_a3 x4_a3 0 1.3081951314894418e-11
Gx4_a3 0 x4_a3 p3 0 0.005580370770981743
Fx4_a3 0 x4_a3 V3 0.2790185385490872
Rp4_a3 0 x4_a3 1.0 noisy=0
Cx5_a3 x5_a3 0 8.108684533816161e-13
Gx5_a3 0 x5_a3 p3 0 0.006251700310673978
Fx5_a3 0 x5_a3 V3 0.3125850155336989
Rp5_a3 0 x5_a3 1.0 noisy=0
V4 p4 s4 0.0
R4 s4 0 50.0 noisy=0
Gd4_1 0 s4 p1 0 -0.001210963616640589
Fd4_1 0 s4 V1 -0.06054818083202946
Gr1_4_1 0 s4 x1_a1 0 0.0072078826986494435
Gr2_4_1 0 s4 x2_a1 0 0.10593661502552004
Gr3_re_4_1 0 s4 x3_re_a1 0 8295.142096130592
Gr3_im_4_1 0 s4 x3_im_a1 0 -4082.277681394702
Gr4_4_1 0 s4 x4_a1 0 0.23398249176187894
Gr5_4_1 0 s4 x5_a1 0 0.2825903089218289
Gd4_2 0 s4 p2 0 -0.00045486388096209707
Fd4_2 0 s4 V2 -0.022743194048104855
Gr1_4_2 0 s4 x1_a2 0 0.222039252746261
Gr2_4_2 0 s4 x2_a2 0 -0.5856166145677476
Gr3_re_4_2 0 s4 x3_re_a2 0 30818.02803156437
Gr3_im_4_2 0 s4 x3_im_a2 0 4398.506330305609
Gr4_4_2 0 s4 x4_a2 0 0.11437818615344818
Gr5_4_2 0 s4 x5_a2 0 0.4957458940888072
Gd4_3 0 s4 p3 0 -0.0008486595004064885
Fd4_3 0 s4 V3 -0.04243297502032443
Gr1_4_3 0 s4 x1_a3 0 0.9861228015320606
Gr2_4_3 0 s4 x2_a3 0 -0.5873014314897325
Gr3_re_4_3 0 s4 x3_re_a3 0 283.0896770549016
Gr3_im_4_3 0 s4 x3_im_a3 0 22895.88834378485
Gr4_4_3 0 s4 x4_a3 0 -0.11088966716096314
Gr5_4_3 0 s4 x5_a3 0 -0.3125850155336989
Gd4_4 0 s4 p4 0 -0.013955658124000582
Fd4_4 0 s4 V4 -0.6977829062000291
Gr1_4_4 0 s4 x1_a4 0 0.3128362306208099
Gr2_4_4 0 s4 x2_a4 0 0.3166857430227307
Gr3_re_4_4 0 s4 x3_re_a4 0 -15211.96330994382
Gr3_im_4_4 0 s4 x3_im_a4 0 -5685.091932336333
Gr4_4_4 0 s4 x4_a4 0 0.19691393317570885
Gr5_4_4 0 s4 x5_a4 0 0.6916391702896577
Gd4_5 0 s4 p5 0 0.00010904750975206287
Fd4_5 0 s4 V5 0.005452375487603143
Gr1_4_5 0 s4 x1_a5 0 0.837239022013372
Gr2_4_5 0 s4 x2_a5 0 0.1233670849551801
Gr3_re_4_5 0 s4 x3_re_a5 0 -23954.83169544193
Gr3_im_4_5 0 s4 x3_im_a5 0 -14528.972982461602
Gr4_4_5 0 s4 x4_a5 0 -0.16044637457837096
Gr5_4_5 0 s4 x5_a5 0 -0.5800058046330632
Gd4_6 0 s4 p6 0 0.00011656876683029856
Fd4_6 0 s4 V6 0.005828438341514928
Gr1_4_6 0 s4 x1_a6 0 -0.0104628157427824
Gr2_4_6 0 s4 x2_a6 0 -0.0018917215400843308
Gr3_re_4_6 0 s4 x3_re_a6 0 912.0919824823243
Gr3_im_4_6 0 s4 x3_im_a6 0 -1083.1972701337904
Gr4_4_6 0 s4 x4_a6 0 -0.1571095417983751
Gr5_4_6 0 s4 x5_a6 0 -0.010121992192525544
Gd4_7 0 s4 p7 0 -8.14232258482824e-05
Fd4_7 0 s4 V7 -0.00407116129241412
Gr1_4_7 0 s4 x1_a7 0 0.005957621969213054
Gr2_4_7 0 s4 x2_a7 0 0.0011045013215162764
Gr3_re_4_7 0 s4 x3_re_a7 0 -818.9896604540096
Gr3_im_4_7 0 s4 x3_im_a7 0 1084.495006568976
Gr4_4_7 0 s4 x4_a7 0 0.15711059980008685
Gr5_4_7 0 s4 x5_a7 0 0.014171848659977383
Gd4_8 0 s4 p8 0 -0.0001332436324450625
Fd4_8 0 s4 V8 -0.0066621816222531246
Gr1_4_8 0 s4 x1_a8 0 0.013835309513761706
Gr2_4_8 0 s4 x2_a8 0 -0.004892325661795685
Gr3_re_4_8 0 s4 x3_re_a8 0 -1697.298321184876
Gr3_im_4_8 0 s4 x3_im_a8 0 1680.6656097092389
Gr4_4_8 0 s4 x4_a8 0 0.24284781490109028
Gr5_4_8 0 s4 x5_a8 0 0.024190258864994863
Gd4_9 0 s4 p9 0 0.00014187488246539793
Fd4_9 0 s4 V9 0.007093744123269896
Gr1_4_9 0 s4 x1_a9 0 -0.010061405492242452
Gr2_4_9 0 s4 x2_a9 0 -0.002173529165138697
Gr3_re_4_9 0 s4 x3_re_a9 0 1591.9311298077084
Gr3_im_4_9 0 s4 x3_im_a9 0 -2072.375782218981
Gr4_4_9 0 s4 x4_a9 0 -0.2431322355447719
Gr5_4_9 0 s4 x5_a9 0 -0.020165347112955884
Gd4_10 0 s4 p10 0 0.0020797594257584377
Fd4_10 0 s4 V10 0.1039879712879219
Gr1_4_10 0 s4 x1_a10 0 -0.051710149942516825
Gr2_4_10 0 s4 x2_a10 0 -0.12009259196090492
Gr3_re_4_10 0 s4 x3_re_a10 0 -1678.0018727252127
Gr3_im_4_10 0 s4 x3_im_a10 0 12524.70192722953
Gr4_4_10 0 s4 x4_a10 0 0.3098366840906724
Gr5_4_10 0 s4 x5_a10 0 -0.5771626967172373
Gd4_11 0 s4 p11 0 0.0002514887265991552
Fd4_11 0 s4 V11 0.01257443632995776
Gr1_4_11 0 s4 x1_a11 0 0.09241118120285274
Gr2_4_11 0 s4 x2_a11 0 0.004760473037395998
Gr3_re_4_11 0 s4 x3_re_a11 0 -7276.219234876382
Gr3_im_4_11 0 s4 x3_im_a11 0 9878.71018284389
Gr4_4_11 0 s4 x4_a11 0 -0.233470765477771
Gr5_4_11 0 s4 x5_a11 0 -0.5464155067030552
Gd4_12 0 s4 p12 0 -0.0010788713341289581
Fd4_12 0 s4 V12 -0.053943566706447905
Gr1_4_12 0 s4 x1_a12 0 0.17323268207579912
Gr2_4_12 0 s4 x2_a12 0 -0.04656496851185957
Gr3_re_4_12 0 s4 x3_re_a12 0 7046.625104303536
Gr3_im_4_12 0 s4 x3_im_a12 0 -26023.68676408452
Gr4_4_12 0 s4 x4_a12 0 -0.2059919364727638
Gr5_4_12 0 s4 x5_a12 0 0.7190928583594213
Gd4_13 0 s4 p13 0 -6.176882857157128e-05
Fd4_13 0 s4 V13 -0.0030884414285785645
Gr1_4_13 0 s4 x1_a13 0 0.003619260859135554
Gr2_4_13 0 s4 x2_a13 0 0.003745627947366433
Gr3_re_4_13 0 s4 x3_re_a13 0 -1318.2761068345962
Gr3_im_4_13 0 s4 x3_im_a13 0 1832.258309706968
Gr4_4_13 0 s4 x4_a13 0 0.18571109541753603
Gr5_4_13 0 s4 x5_a13 0 0.012903463828394104
Gd4_14 0 s4 p14 0 0.00010836599579291676
Fd4_14 0 s4 V14 0.005418299789645839
Gr1_4_14 0 s4 x1_a14 0 -0.005753051015735132
Gr2_4_14 0 s4 x2_a14 0 -0.007064390082252535
Gr3_re_4_14 0 s4 x3_re_a14 0 1307.3041791340988
Gr3_im_4_14 0 s4 x3_im_a14 0 -1749.2314607715439
Gr4_4_14 0 s4 x4_a14 0 -0.18575157930711478
Gr5_4_14 0 s4 x5_a14 0 -0.006548842838822583
Gd4_15 0 s4 p15 0 -0.0001544393667240703
Fd4_15 0 s4 V15 -0.007721968336203516
Gr1_4_15 0 s4 x1_a15 0 0.013029989075679264
Gr2_4_15 0 s4 x2_a15 0 0.00011952693339029346
Gr3_re_4_15 0 s4 x3_re_a15 0 -1033.5586158447616
Gr3_im_4_15 0 s4 x3_im_a15 0 1039.318926649012
Gr4_4_15 0 s4 x4_a15 0 0.1569773708016445
Gr5_4_15 0 s4 x5_a15 0 0.006899612229253024
Cx1_a4 x1_a4 0 1.5871725736917026e-13
Gx1_a4 0 x1_a4 p4 0 0.019722458920055218
Fx1_a4 0 x1_a4 V4 0.986122946002761
Rp1_a4 0 x1_a4 1.0 noisy=0
Cx2_a4 x2_a4 0 3.688153046977837e-13
Gx2_a4 0 x2_a4 p4 0 0.01880725550048075
Fx2_a4 0 x2_a4 V4 0.9403627750240376
Rp2_a4 0 x2_a4 1.0 noisy=0
Cx3_re_a4 x3_re_a4 0 2.3135888003926714e-12
Gx3_re_a4 0 x3_re_a4 p4 0 3.7165632574884326e-09
Fx3_re_a4 0 x3_re_a4 V4 1.8582816287442165e-07
Rp3_re_re_a4 0 x3_re_a4 1.0 noisy=0
Gp3_re_im_a4 0 x3_re_a4 x3_im_a4 0 2.9111243944429863
Cx3_im_a4 x3_im_a4 0 2.3135888003926714e-12
Gp3_im_re_a4 0 x3_im_a4 x3_re_a4 0 -2.9111243944429863
Rp3_im_im_a4 0 x3_im_a4 1.0 noisy=0
Cx4_a4 x4_a4 0 1.3081951314894418e-11
Gx4_a4 0 x4_a4 p4 0 0.009707084623903338
Fx4_a4 0 x4_a4 V4 0.48535423119516696
Rp4_a4 0 x4_a4 1.0 noisy=0
Cx5_a4 x5_a4 0 8.108684533816161e-13
Gx5_a4 0 x5_a4 p4 0 0.014601016218193682
Fx5_a4 0 x5_a4 V4 0.7300508109096842
Rp5_a4 0 x5_a4 1.0 noisy=0
V5 p5 s5 0.0
R5 s5 0 50.0 noisy=0
Gd5_1 0 s5 p1 0 0.0015920356099797203
Fd5_1 0 s5 V1 0.07960178049898602
Gr1_5_1 0 s5 x1_a1 0 -0.07420820273010414
Gr2_5_1 0 s5 x2_a1 0 -0.018681396129842282
Gr3_re_5_1 0 s5 x3_re_a1 0 -4894.02748471375
Gr3_im_5_1 0 s5 x3_im_a1 0 1629.6707687748924
Gr4_5_1 0 s5 x4_a1 0 -0.15427000841440835
Gr5_5_1 0 s5 x5_a1 0 -0.231663508011862
Gd5_2 0 s5 p2 0 0.002721845566830093
Fd5_2 0 s5 V2 0.13609227834150464
Gr1_5_2 0 s5 x1_a2 0 0.0006930745579503544
Gr2_5_2 0 s5 x2_a2 0 -0.19027827114722212
Gr3_re_5_2 0 s5 x3_re_a2 0 14042.477778824397
Gr3_im_5_2 0 s5 x3_im_a2 0 30506.138226280287
Gr4_5_2 0 s5 x4_a2 0 -0.0781108292877629
Gr5_5_2 0 s5 x5_a2 0 -0.5819741156921391
Gd5_3 0 s5 p3 0 0.002563689393519163
Fd5_3 0 s5 V3 0.12818446967595817
Gr1_5_3 0 s5 x1_a3 0 0.6152138899420815
Gr2_5_3 0 s5 x2_a3 0 -0.2252257937349689
Gr3_re_5_3 0 s5 x3_re_a3 0 19637.66542975665
Gr3_im_5_3 0 s5 x3_im_a3 0 25869.863614999602
Gr4_5_3 0 s5 x4_a3 0 0.08145329874256213
Gr5_5_3 0 s5 x5_a3 0 0.12979738034654578
Gd5_4 0 s5 p4 0 0.0001090979677249688
Fd5_4 0 s5 V4 0.00545489838624844
Gr1_5_4 0 s5 x1_a4 0 0.7108269469980834
Gr2_5_4 0 s5 x2_a4 0 0.07032594565687153
Gr3_re_5_4 0 s5 x3_re_a4 0 -22993.435545921366
Gr3_im_5_4 0 s5 x3_im_a4 0 -13944.703274963169
Gr4_5_4 0 s5 x4_a4 0 -0.13025497759182747
Gr5_5_4 0 s5 x5_a4 0 -0.5246559694606168
Gd5_5 0 s5 p5 0 -0.013656672744848563
Fd5_5 0 s5 V5 -0.6828336372424282
Gr1_5_5 0 s5 x1_a5 0 0.37919993534774754
Gr2_5_5 0 s5 x2_a5 0 0.1841349613810613
Gr3_re_5_5 0 s5 x3_re_a5 0 -6756.7543758776055
Gr3_im_5_5 0 s5 x3_im_a5 0 -1910.2196739073518
Gr4_5_5 0 s5 x4_a5 0 0.10499352814448888
Gr5_5_5 0 s5 x5_a5 0 0.5205039807338395
Gd5_6 0 s5 p6 0 -5.530687450239032e-05
Fd5_6 0 s5 V6 -0.002765343725119516
Gr1_5_6 0 s5 x1_a6 0 0.009671602538856135
Gr2_5_6 0 s5 x2_a6 0 -0.006498307085256919
Gr3_re_5_6 0 s5 x3_re_a6 0 -824.3252562327519
Gr3_im_5_6 0 s5 x3_im_a6 0 708.3404686479228
Gr4_5_6 0 s5 x4_a6 0 0.10356791391485556
Gr5_5_6 0 s5 x5_a6 0 0.010913972018483062
Gd5_7 0 s5 p7 0 9.005861939174415e-05
Fd5_7 0 s5 V7 0.004502930969587208
Gr1_5_7 0 s5 x1_a7 0 -0.00834739210923272
Gr2_5_7 0 s5 x2_a7 0 0.003357683287233455
Gr3_re_5_7 0 s5 x3_re_a7 0 774.8524080071807
Gr3_im_5_7 0 s5 x3_im_a7 0 -664.284967774445
Gr4_5_7 0 s5 x4_a7 0 -0.1035997362413666
Gr5_5_7 0 s5 x5_a7 0 -0.013903710672218447
Gd5_8 0 s5 p8 0 0.00025282171096508793
Fd5_8 0 s5 V8 0.012641085548254397
Gr1_5_8 0 s5 x1_a8 0 -0.023756958320506606
Gr2_5_8 0 s5 x2_a8 0 0.012761601453134413
Gr3_re_5_8 0 s5 x3_re_a8 0 1460.954130870389
Gr3_im_5_8 0 s5 x3_im_a8 0 -500.65516463735383
Gr4_5_8 0 s5 x4_a8 0 -0.16017998947618375
Gr5_5_8 0 s5 x5_a8 0 -0.027151229626042658
Gd5_9 0 s5 p9 0 -0.00018376953119605017
Fd5_9 0 s5 V9 -0.00918847655980251
Gr1_5_9 0 s5 x1_a9 0 0.0165978110907468
Gr2_5_9 0 s5 x2_a9 0 -0.007544094332462046
Gr3_re_5_9 0 s5 x3_re_a9 0 -1316.1604478807765
Gr3_im_5_9 0 s5 x3_im_a9 0 903.7980402432379
Gr4_5_9 0 s5 x4_a9 0 0.16035010464661423
Gr5_5_9 0 s5 x5_a9 0 0.02345917427001923
Gd5_10 0 s5 p10 0 -0.0002840325086317052
Fd5_10 0 s5 V10 -0.014201625431585261
Gr1_5_10 0 s5 x1_a10 0 -0.020762333194785126
Gr2_5_10 0 s5 x2_a10 0 0.009496538557646001
Gr3_re_5_10 0 s5 x3_re_a10 0 11475.790813299453
Gr3_im_5_10 0 s5 x3_im_a10 0 23982.642698503645
Gr4_5_10 0 s5 x4_a10 0 -0.204202924841161
Gr5_5_10 0 s5 x5_a10 0 0.4567586376051094
Gd5_11 0 s5 p11 0 4.757934970550733e-06
Fd5_11 0 s5 V11 0.00023789674852753664
Gr1_5_11 0 s5 x1_a11 0 -0.038728487561424045
Gr2_5_11 0 s5 x2_a11 0 -0.08625619861407771
Gr3_re_5_11 0 s5 x3_re_a11 0 4910.27185299243
Gr3_im_5_11 0 s5 x3_im_a11 0 -434.9503241719704
Gr4_5_11 0 s5 x4_a11 0 0.15401576924573881
Gr5_5_11 0 s5 x5_a11 0 0.4558290935422483
Gd5_12 0 s5 p12 0 0.0016986162960817505
Fd5_12 0 s5 V12 0.08493081480408753
Gr1_5_12 0 s5 x1_a12 0 -0.1515143345638036
Gr2_5_12 0 s5 x2_a12 0 0.13715990565141176
Gr3_re_5_12 0 s5 x3_re_a12 0 -5713.243213138063
Gr3_im_5_12 0 s5 x3_im_a12 0 -12720.357447958431
Gr4_5_12 0 s5 x4_a12 0 0.1348551312378875
Gr5_5_12 0 s5 x5_a12 0 -0.5883908449147129
Gd5_13 0 s5 p13 0 8.461772538926506e-05
Fd5_13 0 s5 V13 0.0042308862694632535
Gr1_5_13 0 s5 x1_a13 0 -0.008470173308857768
Gr2_5_13 0 s5 x2_a13 0 0.005710540728913452
Gr3_re_5_13 0 s5 x3_re_a13 0 1003.669031554126
Gr3_im_5_13 0 s5 x3_im_a13 0 -697.2251674467808
Gr4_5_13 0 s5 x4_a13 0 -0.12249105040180298
Gr5_5_13 0 s5 x5_a13 0 -0.01758558222753735
Gd5_14 0 s5 p14 0 -8.69319239965325e-06
Fd5_14 0 s5 V14 -0.0004346596199826625
Gr1_5_14 0 s5 x1_a14 0 0.006692580069290529
Gr2_5_14 0 s5 x2_a14 0 -0.009060952709157771
Gr3_re_5_14 0 s5 x3_re_a14 0 -1004.8779247117311
Gr3_im_5_14 0 s5 x3_im_a14 0 724.0290165261886
Gr4_5_14 0 s5 x4_a14 0 0.12246799076127221
Gr5_5_14 0 s5 x5_a14 0 0.01258239644688211
Gd5_15 0 s5 p15 0 2.778856936805856e-05
Fd5_15 0 s5 V15 0.001389428468402928
Gr1_5_15 0 s5 x1_a15 0 -0.008789711855927645
Gr2_5_15 0 s5 x2_a15 0 0.009962403928126454
Gr3_re_5_15 0 s5 x3_re_a15 0 932.2943194949037
Gr3_im_5_15 0 s5 x3_im_a15 0 -673.8598569038243
Gr4_5_15 0 s5 x4_a15 0 -0.10346793249016928
Gr5_5_15 0 s5 x5_a15 0 -0.008366464411448383
Cx1_a5 x1_a5 0 1.5871725736917026e-13
Gx1_a5 0 x1_a5 p5 0 0.016744780440267438
Fx1_a5 0 x1_a5 V5 0.837239022013372
Rp1_a5 0 x1_a5 1.0 noisy=0
Cx2_a5 x2_a5 0 3.688153046977837e-13
Gx2_a5 0 x2_a5 p5 0 0.010720364978362675
Fx2_a5 0 x2_a5 V5 0.5360182489181338
Rp2_a5 0 x2_a5 1.0 noisy=0
Cx3_re_a5 x3_re_a5 0 2.3135888003926714e-12
Gx3_re_a5 0 x3_re_a5 p5 0 3.5675850874805984e-09
Fx3_re_a5 0 x3_re_a5 V5 1.7837925437402993e-07
Rp3_re_re_a5 0 x3_re_a5 1.0 noisy=0
Gp3_re_im_a5 0 x3_re_a5 x3_im_a5 0 2.9111243944429863
Cx3_im_a5 x3_im_a5 0 2.3135888003926714e-12
Gp3_im_re_a5 0 x3_im_a5 x3_re_a5 0 -2.9111243944429863
Rp3_im_im_a5 0 x3_im_a5 1.0 noisy=0
Cx4_a5 x4_a5 0 1.3081951314894418e-11
Gx4_a5 0 x4_a5 p5 0 0.007880492339248356
Fx4_a5 0 x4_a5 V5 0.3940246169624178
Rp4_a5 0 x4_a5 1.0 noisy=0
Cx5_a5 x5_a5 0 8.108684533816161e-13
Gx5_a5 0 x5_a5 p5 0 0.013207612487009282
Fx5_a5 0 x5_a5 V5 0.6603806243504642
Rp5_a5 0 x5_a5 1.0 noisy=0
V6 p6 s6 0.0
R6 s6 0 50.0 noisy=0
Gd6_1 0 s6 p1 0 -9.472783172201373e-06
Fd6_1 0 s6 V1 -0.0004736391586100687
Gr1_6_1 0 s6 x1_a1 0 0.00019728390276393723
Gr2_6_1 0 s6 x2_a1 0 -0.0007350109575686431
Gr3_re_6_1 0 s6 x3_re_a1 0 2810.459704804973
Gr3_im_6_1 0 s6 x3_im_a1 0 -3368.4159512603933
Gr4_6_1 0 s6 x4_a1 0 -0.14677970143831107
Gr5_6_1 0 s6 x5_a1 0 0.0019413483392130698
Gd6_2 0 s6 p2 0 4.0240899004998043e-05
Fd6_2 0 s6 V2 0.0020120449502499024
Gr1_6_2 0 s6 x1_a2 0 -0.0026133096943748223
Gr2_6_2 0 s6 x2_a2 0 0.0018290172636688132
Gr3_re_6_2 0 s6 x3_re_a2 0 196.02314266045803
Gr3_im_6_2 0 s6 x3_im_a2 0 -939.6632326804215
Gr4_6_2 0 s6 x4_a2 0 -0.07214064106637581
Gr5_6_2 0 s6 x5_a2 0 -0.001753773553675641
Gd6_3 0 s6 p3 0 -4.049309547374719e-05
Fd6_3 0 s6 V3 -0.0020246547736873597
Gr1_6_3 0 s6 x1_a3 0 0.0037880635565780193
Gr2_6_3 0 s6 x2_a3 0 -0.0011353168361228807
Gr3_re_6_3 0 s6 x3_re_a3 0 -640.6128559317083
Gr3_im_6_3 0 s6 x3_im_a3 0 43.105182468958255
Gr4_6_3 0 s6 x4_a3 0 0.07169828958815859
Gr5_6_3 0 s6 x5_a3 0 0.0017027615470661065
Gd6_4 0 s6 p4 0 0.00011657017459706702
Fd6_4 0 s6 V4 0.005828508729853351
Gr1_6_4 0 s6 x1_a4 0 -0.006378846061846122
Gr2_6_4 0 s6 x2_a4 0 -0.0007585801090038712
Gr3_re_6_4 0 s6 x3_re_a4 0 1695.8334332385082
Gr3_im_6_4 0 s6 x3_im_a4 0 -2013.923312291245
Gr4_6_4 0 s6 x4_a4 0 -0.1248086876648526
Gr5_6_4 0 s6 x5_a4 0 -0.0019825844497675946
Gd6_5 0 s6 p5 0 -5.5306479930554156e-05
Fd6_5 0 s6 V5 -0.002765323996527708
Gr1_6_5 0 s6 x1_a5 0 0.006944739527389672
Gr2_6_5 0 s6 x2_a5 0 -0.0045723170606874475
Gr3_re_6_5 0 s6 x3_re_a5 0 -1596.6603371284166
Gr3_im_6_5 0 s6 x3_im_a5 0 1372.0449345424925
Gr4_6_5 0 s6 x4_a5 0 0.1013451504114191
Gr5_6_5 0 s6 x5_a5 0 0.0023631504788349527
Gd6_6 0 s6 p6 0 0.0046021317041423804
Fd6_6 0 s6 V6 0.23010658520711905
Gr1_6_6 0 s6 x1_a6 0 0.5931298664280783
Gr2_6_6 0 s6 x2_a6 0 -0.17904907550759624
Gr3_re_6_6 0 s6 x3_re_a6 0 29529.646079292703
Gr3_im_6_6 0 s6 x3_im_a6 0 19650.395434760747
Gr4_6_6 0 s6 x4_a6 0 0.09842889872133204
Gr5_6_6 0 s6 x5_a6 0 0.0031289227620741695
Gd6_7 0 s6 p7 0 0.004965891469375113
Fd6_7 0 s6 V7 0.2482945734687556
Gr1_6_7 0 s6 x1_a7 0 0.45030736115955006
Gr2_6_7 0 s6 x2_a7 0 -0.2661428646141566
Gr3_re_6_7 0 s6 x3_re_a7 0 -37418.803205410404
Gr3_im_6_7 0 s6 x3_im_a7 0 -16965.780256075825
Gr4_6_7 0 s6 x4_a7 0 -0.09814125036565637
Gr5_6_7 0 s6 x5_a7 0 0.09091300672217427
Gd6_8 0 s6 p8 0 -7.070381820802273e-05
Fd6_8 0 s6 V8 -0.0035351909104011365
Gr1_6_8 0 s6 x1_a8 0 0.44654623983906655
Gr2_6_8 0 s6 x2_a8 0 -0.26081089729804313
Gr3_re_6_8 0 s6 x3_re_a8 0 -51587.17883774453
Gr3_im_6_8 0 s6 x3_im_a8 0 -29184.49770837026
Gr4_6_8 0 s6 x4_a8 0 -0.15210073764679324
Gr5_6_8 0 s6 x5_a8 0 0.09452035975766612
Gd6_9 0 s6 p9 0 -0.0005594930265638481
Fd6_9 0 s6 V9 -0.02797465132819241
Gr1_6_9 0 s6 x1_a9 0 -0.3969165771217294
Gr2_6_9 0 s6 x2_a9 0 0.24221978573594913
Gr3_re_6_9 0 s6 x3_re_a9 0 53582.48423360819
Gr3_im_6_9 0 s6 x3_im_a9 0 27674.812004580363
Gr4_6_9 0 s6 x4_a9 0 0.1523549330339957
Gr5_6_9 0 s6 x5_a9 0 -0.09170162124397468
Gd6_10 0 s6 p10 0 0.00012419062403150539
Fd6_10 0 s6 V10 0.006209531201575269
Gr1_6_10 0 s6 x1_a10 0 -0.008830886847358397
Gr2_6_10 0 s6 x2_a10 0 0.001882280483361881
Gr3_re_6_10 0 s6 x3_re_a10 0 3632.697013913351
Gr3_im_6_10 0 s6 x3_im_a10 0 -2154.8280989713385
Gr4_6_10 0 s6 x4_a10 0 -0.19553180072487045
Gr5_6_10 0 s6 x5_a10 0 0.0012522432202684657
Gd6_11 0 s6 p11 0 3.8984876588455624e-06
Fd6_11 0 s6 V11 0.00019492438294227814
Gr1_6_11 0 s6 x1_a11 0 -0.004850536637091747
Gr2_6_11 0 s6 x2_a11 0 0.005734595244443799
Gr3_re_6_11 0 s6 x3_re_a11 0 -2622.788438633169
Gr3_im_6_11 0 s6 x3_im_a11 0 3693.4172509725117
Gr4_6_11 0 s6 x4_a11 0 0.146464122311342
Gr5_6_11 0 s6 x5_a11 0 -0.0008167705271373896
Gd6_12 0 s6 p12 0 9.508930056978722e-06
Fd6_12 0 s6 V12 0.00047544650284893613
Gr1_6_12 0 s6 x1_a12 0 -0.002952612677004025
Gr2_6_12 0 s6 x2_a12 0 0.0011323142185071164
Gr3_re_6_12 0 s6 x3_re_a12 0 -23.536696693395413
Gr3_im_6_12 0 s6 x3_im_a12 0 1523.1152475211961
Gr4_6_12 0 s6 x4_a12 0 0.13015265987508087
Gr5_6_12 0 s6 x5_a12 0 -0.0018678142696377787
Gd6_13 0 s6 p13 0 -0.0016462190229765623
Fd6_13 0 s6 V13 -0.08231095114882812
Gr1_6_13 0 s6 x1_a13 0 -0.22420478615529826
Gr2_6_13 0 s6 x2_a13 0 0.038707511015930285
Gr3_re_6_13 0 s6 x3_re_a13 0 -36899.87692226243
Gr3_im_6_13 0 s6 x3_im_a13 0 -20720.65280467136
Gr4_6_13 0 s6 x4_a13 0 -0.11658157184009244
Gr5_6_13 0 s6 x5_a13 0 0.017238805013922363
Gd6_14 0 s6 p14 0 4.8643337509662384e-05
Fd6_14 0 s6 V14 0.0024321668754831195
Gr1_6_14 0 s6 x1_a14 0 0.3483047337450781
Gr2_6_14 0 s6 x2_a14 0 -0.0877091468022643
Gr3_re_6_14 0 s6 x3_re_a14 0 34594.49800952665
Gr3_im_6_14 0 s6 x3_im_a14 0 20318.315577481033
Gr4_6_14 0 s6 x4_a14 0 0.11675020058535707
Gr5_6_14 0 s6 x5_a14 0 -0.006945333353524491
Gd6_15 0 s6 p15 0 0.005729684927145112
Fd6_15 0 s6 V15 0.2864842463572556
Gr1_6_15 0 s6 x1_a15 0 0.40826315007243846
Gr2_6_15 0 s6 x2_a15 0 -0.2902178494287503
Gr3_re_6_15 0 s6 x3_re_a15 0 -37718.82186265466
Gr3_im_6_15 0 s6 x3_im_a15 0 -19535.505953615655
Gr4_6_15 0 s6 x4_a15 0 -0.09862107010997877
Gr5_6_15 0 s6 x5_a15 0 0.10060399194890882
Cx1_a6 x1_a6 0 1.5871725736917026e-13
Gx1_a6 0 x1_a6 p6 0 0.012023811224775043
Fx1_a6 0 x1_a6 V6 0.6011905612387523
Rp1_a6 0 x1_a6 1.0 noisy=0
Cx2_a6 x2_a6 0 3.688153046977837e-13
Gx2_a6 0 x2_a6 p6 0 0.007543248056606898
Fx2_a6 0 x2_a6 V6 0.3771624028303449
Rp2_a6 0 x2_a6 1.0 noisy=0
Cx3_re_a6 x3_re_a6 0 2.3135888003926714e-12
Gx3_re_a6 0 x3_re_a6 p6 0 6.910113671455763e-09
Fx3_re_a6 0 x3_re_a6 V6 3.455056835727881e-07
Rp3_re_re_a6 0 x3_re_a6 1.0 noisy=0
Gp3_re_im_a6 0 x3_re_a6 x3_im_a6 0 2.9111243944429863
Cx3_im_a6 x3_im_a6 0 2.3135888003926714e-12
Gp3_im_re_a6 0 x3_im_a6 x3_re_a6 0 -2.9111243944429863
Rp3_im_im_a6 0 x3_im_a6 1.0 noisy=0
Cx4_a6 x4_a6 0 1.3081951314894418e-11
Gx4_a6 0 x4_a6 p6 0 0.0077113619683157105
Fx4_a6 0 x4_a6 V6 0.38556809841578554
Rp4_a6 0 x4_a6 1.0 noisy=0
Cx5_a6 x5_a6 0 8.108684533816161e-13
Gx5_a6 0 x5_a6 p6 0 0.0028598180335360768
Fx5_a6 0 x5_a6 V6 0.14299090167680384
Rp5_a6 0 x5_a6 1.0 noisy=0
V7 p7 s7 0.0
R7 s7 0 50.0 noisy=0
Gd7_1 0 s7 p1 0 1.1423361307738313e-05
Fd7_1 0 s7 V1 0.0005711680653869157
Gr1_7_1 0 s7 x1_a1 0 -0.0030147700528712403
Gr2_7_1 0 s7 x2_a1 0 0.0035392034677628244
Gr3_re_7_1 0 s7 x3_re_a1 0 -2518.3785652271436
Gr3_im_7_1 0 s7 x3_im_a1 0 3275.211210741737
Gr4_7_1 0 s7 x4_a1 0 0.14675270451731945
Gr5_7_1 0 s7 x5_a1 0 -0.0021266786404809186
Gd7_2 0 s7 p2 0 -1.612113079706908e-05
Fd7_2 0 s7 V2 -0.0008060565398534539
Gr1_7_2 0 s7 x1_a2 0 -9.133922663377106e-05
Gr2_7_2 0 s7 x2_a2 0 0.0001798968926278036
Gr3_re_7_2 0 s7 x3_re_a2 0 -78.26870859501241
Gr3_im_7_2 0 s7 x3_im_a2 0 830.4342935829934
Gr4_7_2 0 s7 x4_a2 0 0.07215964451511164
Gr5_7_2 0 s7 x5_a2 0 0.0025070570763253484
Gd7_3 0 s7 p3 0 5.975430379627345e-05
Fd7_3 0 s7 V3 0.0029877151898136723
Gr1_7_3 0 s7 x1_a3 0 -0.005288910791608973
Gr2_7_3 0 s7 x2_a3 0 0.0015306892048697954
Gr3_re_7_3 0 s7 x3_re_a3 0 547.4940788688009
Gr3_im_7_3 0 s7 x3_im_a3 0 -199.4963348800399
Gr4_7_3 0 s7 x4_a3 0 -0.07168911512744067
Gr5_7_3 0 s7 x5_a3 0 -0.00147602397863865
Gd7_4 0 s7 p4 0 -8.142438379975067e-05
Fd7_4 0 s7 V4 -0.004071219189987534
Gr1_7_4 0 s7 x1_a4 0 0.004351575061213663
Gr2_7_4 0 s7 x2_a4 0 0.00046329395922653065
Gr3_re_7_4 0 s7 x3_re_a4 0 -1523.5971132416998
Gr3_im_7_4 0 s7 x3_im_a4 0 2017.477643905229
Gr4_7_4 0 s7 x4_a4 0 0.12477428692605054
Gr5_7_4 0 s7 x5_a4 0 0.0027680596594307503
Gd7_5 0 s7 p5 0 9.005965345669506e-05
Fd7_5 0 s7 V5 0.004502982672834753
Gr1_7_5 0 s7 x1_a5 0 -0.007181295237381126
Gr2_7_5 0 s7 x2_a5 0 0.002471320833070723
Gr3_re_7_5 0 s7 x3_re_a5 0 1501.6682114234204
Gr3_im_7_5 0 s7 x3_im_a5 0 -1287.3398366472613
Gr4_7_5 0 s7 x4_a5 0 -0.10134766064969307
Gr5_7_5 0 s7 x5_a5 0 -0.0030022027247477295
Gd7_6 0 s7 p6 0 0.004965881666163177
Fd7_6 0 s7 V6 0.24829408330815883
Gr1_7_6 0 s7 x1_a6 0 0.5395006022354457
Gr2_7_6 0 s7 x2_a6 0 -0.2783791837680716
Gr3_re_7_6 0 s7 x3_re_a6 0 -37438.802750654606
Gr3_im_7_6 0 s7 x3_im_a6 0 -16975.448232095812
Gr4_7_6 0 s7 x4_a6 0 -0.0981135397069397
Gr5_7_6 0 s7 x5_a6 0 0.09066342509589281
Gd7_7 0 s7 p7 0 0.004520623939626238
Fd7_7 0 s7 V7 0.2260311969813119
Gr1_7_7 0 s7 x1_a7 0 0.5149053985135337
Gr2_7_7 0 s7 x2_a7 0 -0.20240199841418288
Gr3_re_7_7 0 s7 x3_re_a7 0 28363.086699132087
Gr3_im_7_7 0 s7 x3_im_a7 0 19160.147482547596
Gr4_7_7 0 s7 x4_a7 0 0.0983697114896781
Gr5_7_7 0 s7 x5_a7 0 0.018864551568135744
Gd7_8 0 s7 p8 0 -0.0009845052961842105
Fd7_8 0 s7 V8 -0.04922526480921052
Gr1_7_8 0 s7 x1_a8 0 -0.3689933805502239
Gr2_7_8 0 s7 x2_a8 0 0.24245156469477905
Gr3_re_7_8 0 s7 x3_re_a8 0 49815.434155689705
Gr3_im_7_8 0 s7 x3_im_a8 0 30239.14159734935
Gr4_7_8 0 s7 x4_a8 0 0.15221299206310104
Gr5_7_8 0 s7 x5_a8 0 -0.09399463353871264
Gd7_9 0 s7 p9 0 0.0035708324378549983
Fd7_9 0 s7 V9 0.1785416218927499
Gr1_7_9 0 s7 x1_a9 0 0.15883476669571833
Gr2_7_9 0 s7 x2_a9 0 -0.15733267149813462
Gr3_re_7_9 0 s7 x3_re_a9 0 -51823.903636106894
Gr3_im_7_9 0 s7 x3_im_a9 0 -28553.912482487023
Gr4_7_9 0 s7 x4_a9 0 -0.15239786006425826
Gr5_7_9 0 s7 x5_a9 0 0.07128857075815831
Gd7_10 0 s7 p10 0 -0.0001067278537588219
Fd7_10 0 s7 V10 -0.005336392687941095
Gr1_7_10 0 s7 x1_a10 0 0.012253942388682715
Gr2_7_10 0 s7 x2_a10 0 -0.006775512825021021
Gr3_re_7_10 0 s7 x3_re_a10 0 -3979.9610555425766
Gr3_im_7_10 0 s7 x3_im_a10 0 1511.3927060651547
Gr4_7_10 0 s7 x4_a10 0 0.19542137758720657
Gr5_7_10 0 s7 x5_a10 0 -0.001020792699885649
Gd7_11 0 s7 p11 0 2.3711573215397373e-05
Fd7_11 0 s7 V11 0.0011855786607698686
Gr1_7_11 0 s7 x1_a11 0 0.0004316831886715616
Gr2_7_11 0 s7 x2_a11 0 -0.0027332269604526263
Gr3_re_7_11 0 s7 x3_re_a11 0 2940.0507491491435
Gr3_im_7_11 0 s7 x3_im_a11 0 -3618.8102890520463
Gr4_7_11 0 s7 x4_a11 0 -0.14642226518051205
Gr5_7_11 0 s7 x5_a11 0 -0.00016982245029139898
Gd7_12 0 s7 p12 0 3.457424332070071e-05
Fd7_12 0 s7 V12 0.0017287121660350356
Gr1_7_12 0 s7 x1_a12 0 -0.00033181964341153853
Gr2_7_12 0 s7 x2_a12 0 -0.0013355773409680386
Gr3_re_7_12 0 s7 x3_re_a12 0 236.32636300216353
Gr3_im_7_12 0 s7 x3_im_a12 0 -1144.7972180196377
Gr4_7_12 0 s7 x4_a12 0 -0.13010627057974872
Gr5_7_12 0 s7 x5_a12 0 0.002617630382538617
Gd7_13 0 s7 p13 0 0.004630991582262459
Fd7_13 0 s7 V13 0.23154957911312296
Gr1_7_13 0 s7 x1_a13 0 -0.01086390501184054
Gr2_7_13 0 s7 x2_a13 0 0.05994464253725825
Gr3_re_7_13 0 s7 x3_re_a13 0 38421.65723682503
Gr3_im_7_13 0 s7 x3_im_a13 0 20355.031776370015
Gr4_7_13 0 s7 x4_a13 0 0.1163634079824493
Gr5_7_13 0 s7 x5_a13 0 -0.042397972135953685
Gd7_14 0 s7 p14 0 -0.0011069282253708562
Fd7_14 0 s7 V14 -0.05534641126854282
Gr1_7_14 0 s7 x1_a14 0 -0.2727493820432578
Gr2_7_14 0 s7 x2_a14 0 0.06902754606863983
Gr3_re_7_14 0 s7 x3_re_a14 0 -36304.38699348215
Gr3_im_7_14 0 s7 x3_im_a14 0 -20311.37638927201
Gr4_7_14 0 s7 x4_a14 0 -0.11652109252477351
Gr5_7_14 0 s7 x5_a14 0 0.007229299904783399
Gd7_15 0 s7 p15 0 -0.0019973815223914395
Fd7_15 0 s7 V15 -0.09986907611957198
Gr1_7_15 0 s7 x1_a15 0 -0.7202666564447845
Gr2_7_15 0 s7 x2_a15 0 0.39449757523145557
Gr3_re_7_15 0 s7 x3_re_a15 0 39373.15220194243
Gr3_im_7_15 0 s7 x3_im_a15 0 17497.884881507987
Gr4_7_15 0 s7 x4_a15 0 0.09806980923641807
Gr5_7_15 0 s7 x5_a15 0 -0.1211087571775713
Cx1_a7 x1_a7 0 1.5871725736917026e-13
Gx1_a7 0 x1_a7 p7 0 0.014405320238867087
Fx1_a7 0 x1_a7 V7 0.7202660119433544
Rp1_a7 0 x1_a7 1.0 noisy=0
Cx2_a7 x2_a7 0 3.688153046977837e-13
Gx2_a7 0 x2_a7 p7 0 0.007889944497970893
Fx2_a7 0 x2_a7 V7 0.3944972248985447
Rp2_a7 0 x2_a7 1.0 noisy=0
Cx3_re_a7 x3_re_a7 0 2.3135888003926714e-12
Gx3_re_a7 0 x3_re_a7 p7 0 6.913823055911987e-09
Fx3_re_a7 0 x3_re_a7 V7 3.456911527955993e-07
Rp3_re_re_a7 0 x3_re_a7 1.0 noisy=0
Gp3_re_im_a7 0 x3_re_a7 x3_im_a7 0 2.9111243944429863
Cx3_im_a7 x3_im_a7 0 2.3135888003926714e-12
Gp3_im_re_a7 0 x3_im_a7 x3_re_a7 0 -2.9111243944429863
Rp3_im_im_a7 0 x3_im_a7 1.0 noisy=0
Cx4_a7 x4_a7 0 1.3081951314894418e-11
Gx4_a7 0 x4_a7 p7 0 0.007709184253863132
Fx4_a7 0 x4_a7 V7 0.38545921269315664
Rp4_a7 0 x4_a7 1.0 noisy=0
Cx5_a7 x5_a7 0 8.108684533816161e-13
Gx5_a7 0 x5_a7 p7 0 0.002851881227811861
Fx5_a7 0 x5_a7 V7 0.14259406139059305
Rp5_a7 0 x5_a7 1.0 noisy=0
V8 p8 s8 0.0
R8 s8 0 50.0 noisy=0
Gd8_1 0 s8 p1 0 -7.91412852265519e-05
Fd8_1 0 s8 V1 -0.003957064261327595
Gr1_8_1 0 s8 x1_a1 0 -0.0036219937801329613
Gr2_8_1 0 s8 x2_a1 0 0.008208972268934314
Gr3_re_8_1 0 s8 x3_re_a1 0 -4712.184233762085
Gr3_im_8_1 0 s8 x3_im_a1 0 6213.108871006394
Gr4_8_1 0 s8 x4_a1 0 0.3504204452006953
Gr5_8_1 0 s8 x5_a1 0 -0.0026692774129100697
Gd8_2 0 s8 p2 0 5.4809185445690166e-05
Fd8_2 0 s8 V2 0.0027404592722845085
Gr1_8_2 0 s8 x1_a2 0 -0.00471346760367917
Gr2_8_2 0 s8 x2_a2 0 0.0026460474857706645
Gr3_re_8_2 0 s8 x3_re_a2 0 -745.702450413565
Gr3_im_8_2 0 s8 x3_im_a2 0 2229.6732581049587
Gr4_8_2 0 s8 x4_a2 0 0.17234698367993662
Gr5_8_2 0 s8 x5_a2 0 0.006197402707439872
Gd8_3 0 s8 p3 0 0.00011291402307133615
Fd8_3 0 s8 V3 0.005645701153566808
Gr1_8_3 0 s8 x1_a3 0 -0.011802850072241734
Gr2_8_3 0 s8 x2_a3 0 0.0035374365780369735
Gr3_re_8_3 0 s8 x3_re_a3 0 1739.2464166811071
Gr3_im_8_3 0 s8 x3_im_a3 0 -1112.0834658823683
Gr4_8_3 0 s8 x4_a3 0 -0.17106593201218748
Gr5_8_3 0 s8 x5_a3 0 -0.00197599772777866
Gd8_4 0 s8 p4 0 -0.0001332363964698087
Fd8_4 0 s8 V4 -0.006661819823490436
Gr1_8_4 0 s8 x1_a4 0 0.011354864198861291
Gr2_8_4 0 s8 x2_a4 0 -0.0028369015845792723
Gr3_re_8_4 0 s8 x3_re_a4 0 -4962.071197739066
Gr3_im_8_4 0 s8 x3_im_a4 0 4913.855398029251
Gr4_8_4 0 s8 x4_a4 0 0.2978949514760264
Gr5_8_4 0 s8 x5_a4 0 0.007167617808539241
Gd8_5 0 s8 p5 0 0.0002528224690885157
Fd8_5 0 s8 V5 0.012641123454425784
Gr1_8_5 0 s8 x1_a5 0 -0.02296696813917684
Gr2_8_5 0 s8 x2_a5 0 0.012985801327448122
Gr3_re_8_5 0 s8 x3_re_a5 0 4449.624667154568
Gr3_im_8_5 0 s8 x3_im_a5 0 -1524.7421807648964
Gr4_8_5 0 s8 x4_a5 0 -0.24203192465621767
Gr5_8_5 0 s8 x5_a5 0 -0.008893968748869554
Gd8_6 0 s8 p6 0 -7.069686868815819e-05
Fd8_6 0 s8 V6 -0.0035348434344079096
Gr1_8_6 0 s8 x1_a6 0 0.6011905612387521
Gr2_8_6 0 s8 x2_a6 0 -0.3771624028303449
Gr3_re_8_6 0 s8 x3_re_a6 0 -81118.391969299
Gr3_im_8_6 0 s8 x3_im_a6 0 -45890.75312729652
Gr4_8_6 0 s8 x4_a6 0 -0.2348648303054639
Gr5_8_6 0 s8 x5_a6 0 0.14299090167680384
Gd8_7 0 s8 p7 0 -0.000984513792820508
Fd8_7 0 s8 V7 -0.04922568964102541
Gr1_8_7 0 s8 x1_a7 0 -0.41465209831809846
Gr2_8_7 0 s8 x2_a7 0 0.33520851440031785
Gr3_re_8_7 0 s8 x3_re_a7 0 78289.9371309123
Gr3_im_8_7 0 s8 x3_im_a7 0 47524.23526114776
Gr4_8_7 0 s8 x4_a7 0 0.2351045786938665
Gr5_8_7 0 s8 x5_a7 0 -0.14259406139059305
Gd8_8 0 s8 p8 0 0.004397154125010829
Fd8_8 0 s8 V8 0.2198577062505415
Gr1_8_8 0 s8 x1_a8 0 0.1862453184323262
Gr2_8_8 0 s8 x2_a8 0 0.17557358483037927
Gr3_re_8_8 0 s8 x3_re_a8 0 108444.82420662076
Gr3_im_8_8 0 s8 x3_im_a8 0 79276.07194238594
Gr4_8_8 0 s8 x4_a8 0 0.3631542019805818
Gr5_8_8 0 s8 x5_a8 0 -0.13469051423464645
Gd8_9 0 s8 p9 0 0.0032126040465697025
Fd8_9 0 s8 V9 0.16063020232848513
Gr1_8_9 0 s8 x1_a9 0 0.8093919961809087
Gr2_8_9 0 s8 x2_a9 0 -0.5454238386321444
Gr3_re_8_9 0 s8 x3_re_a9 0 -120596.71524448853
Gr3_im_8_9 0 s8 x3_im_a9 0 -74069.413468874
Gr4_8_9 0 s8 x4_a9 0 -0.36370101960706647
Gr5_8_9 0 s8 x5_a9 0 0.21632044210630477
Gd8_10 0 s8 p10 0 -0.00034859719087086335
Fd8_10 0 s8 V10 -0.017429859543543168
Gr1_8_10 0 s8 x1_a10 0 0.05061076180176555
Gr2_8_10 0 s8 x2_a10 0 -0.03586694964373802
Gr3_re_8_10 0 s8 x3_re_a10 0 -10267.974144741993
Gr3_im_8_10 0 s8 x3_im_a10 0 -2279.778665354794
Gr4_8_10 0 s8 x4_a10 0 0.4662197896587679
Gr5_8_10 0 s8 x5_a10 0 0.002556261813018326
Gd8_11 0 s8 p11 0 0.00016098009913904492
Fd8_11 0 s8 V11 0.008049004956952247
Gr1_8_11 0 s8 x1_a11 0 -0.012407509175639939
Gr2_8_11 0 s8 x2_a11 0 0.001724947377753359
Gr3_re_8_11 0 s8 x3_re_a11 0 7170.91507673866
Gr3_im_8_11 0 s8 x3_im_a11 0 -5654.243442321304
Gr4_8_11 0 s8 x4_a11 0 -0.3495887828023716
Gr5_8_11 0 s8 x5_a11 0 -0.004356402493189258
Gd8_12 0 s8 p12 0 0.00011678823685985528
Fd8_12 0 s8 V12 0.005839411842992764
Gr1_8_12 0 s8 x1_a12 0 -0.005772075129970431
Gr2_8_12 0 s8 x2_a12 0 -0.0016059981955199836
Gr3_re_8_12 0 s8 x3_re_a12 0 2051.1180305798875
Gr3_im_8_12 0 s8 x3_im_a12 0 -3178.0845572399007
Gr4_8_12 0 s8 x4_a12 0 -0.31061831767401443
Gr5_8_12 0 s8 x5_a12 0 0.007208626942005725
Gd8_13 0 s8 p13 0 -9.999492770770977e-05
Fd8_13 0 s8 V13 -0.0049997463853854885
Gr1_8_13 0 s8 x1_a13 0 -0.5996778536660838
Gr2_8_13 0 s8 x2_a13 0 0.40899065090472864
Gr3_re_8_13 0 s8 x3_re_a13 0 94551.5085010181
Gr3_im_8_13 0 s8 x3_im_a13 0 53845.95739964578
Gr4_8_13 0 s8 x4_a13 0 0.2777474302003061
Gr5_8_13 0 s8 x5_a13 0 -0.1679268826372653
Gd8_14 0 s8 p14 0 -0.0017029733378525044
Fd8_14 0 s8 V14 -0.08514866689262522
Gr1_8_14 0 s8 x1_a14 0 0.734245613337406
Gr2_8_14 0 s8 x2_a14 0 -0.451033558351249
Gr3_re_8_14 0 s8 x3_re_a14 0 -98532.4165337455
Gr3_im_8_14 0 s8 x3_im_a14 0 -51838.742542040985
Gr4_8_14 0 s8 x4_a14 0 -0.27760828513642655
Gr5_8_14 0 s8 x5_a14 0 0.17004828515148562
Gd8_15 0 s8 p15 0 0.00016637725422422858
Fd8_15 0 s8 V15 0.00831886271121143
Gr1_8_15 0 s8 x1_a15 0 -0.513748320950618
Gr2_8_15 0 s8 x2_a15 0 0.37253449201944183
Gr3_re_8_15 0 s8 x3_re_a15 0 79942.55038480721
Gr3_im_8_15 0 s8 x3_im_a15 0 47319.247377738124
Gr4_8_15 0 s8 x4_a15 0 0.23470280018561415
Gr5_8_15 0 s8 x5_a15 0 -0.14484211787307993
Cx1_a8 x1_a8 0 1.5871725736917026e-13
Gx1_a8 0 x1_a8 p8 0 0.016187852686394492
Fx1_a8 0 x1_a8 V8 0.8093926343197246
Rp1_a8 0 x1_a8 1.0 noisy=0
Cx2_a8 x2_a8 0 3.688153046977837e-13
Gx2_a8 0 x2_a8 p8 0 0.010908487584044167
Fx2_a8 0 x2_a8 V8 0.5454243792022084
Rp2_a8 0 x2_a8 1.0 noisy=0
Cx3_re_a8 x3_re_a8 0 2.3135888003926714e-12
Gx3_re_a8 0 x3_re_a8 p8 0 1.0865812155968828e-08
Fx3_re_a8 0 x3_re_a8 V8 5.432906077984414e-07
Rp3_re_re_a8 0 x3_re_a8 1.0 noisy=0
Gp3_re_im_a8 0 x3_re_a8 x3_im_a8 0 2.9111243944429863
Cx3_im_a8 x3_im_a8 0 2.3135888003926714e-12
Gp3_im_re_a8 0 x3_im_a8 x3_re_a8 0 -2.9111243944429863
Rp3_im_im_a8 0 x3_im_a8 1.0 noisy=0
Cx4_a8 x4_a8 0 1.3081951314894418e-11
Gx4_a8 0 x4_a8 p8 0 0.011907421980268288
Fx4_a8 0 x4_a8 V8 0.5953710990134145
Rp4_a8 0 x4_a8 1.0 noisy=0
Cx5_a8 x5_a8 0 8.108684533816161e-13
Gx5_a8 0 x5_a8 p8 0 0.004326411098331482
Fx5_a8 0 x5_a8 V8 0.21632055491657412
Rp5_a8 0 x5_a8 1.0 noisy=0
V9 p9 s9 0.0
R9 s9 0 50.0 noisy=0
Gd9_1 0 s9 p1 0 6.511524503546515e-05
Fd9_1 0 s9 V1 0.0032557622517732578
Gr1_9_1 0 s9 x1_a1 0 0.0035593836420923
Gr2_9_1 0 s9 x2_a1 0 -0.007513714463940979
Gr3_re_9_1 0 s9 x3_re_a1 0 4867.029081126862
Gr3_im_9_1 0 s9 x3_im_a1 0 -7151.408105579465
Gr4_9_1 0 s9 x4_a1 0 -0.3514680382077263
Gr5_9_1 0 s9 x5_a1 0 0.0039096929767535055
Gd9_2 0 s9 p2 0 -2.4518943097698692e-05
Fd9_2 0 s9 V2 -0.0012259471548849348
Gr1_9_2 0 s9 x1_a2 0 0.001954018272827607
Gr2_9_2 0 s9 x2_a2 0 -0.00044804384149544295
Gr3_re_9_2 0 s9 x3_re_a2 0 926.169471856027
Gr3_im_9_2 0 s9 x3_im_a2 0 -2294.2273382038165
Gr4_9_2 0 s9 x4_a2 0 -0.1727773525245075
Gr5_9_2 0 s9 x5_a2 0 -0.005956247681618003
Gd9_3 0 s9 p3 0 -8.156449115363128e-05
Fd9_3 0 s9 V3 -0.004078224557681564
Gr1_9_3 0 s9 x1_a3 0 0.007703971755855243
Gr2_9_3 0 s9 x2_a3 0 -0.0010380361304335028
Gr3_re_9_3 0 s9 x3_re_a3 0 -1550.3207453153886
Gr3_im_9_3 0 s9 x3_im_a3 0 1603.45885913404
Gr4_9_3 0 s9 x4_a3 0 0.1716441153529997
Gr5_9_3 0 s9 x5_a3 0 0.0007555381525282057
Gd9_4 0 s9 p4 0 0.0001418753585240074
Fd9_4 0 s9 V4 0.007093767926200371
Gr1_9_4 0 s9 x1_a4 0 -0.008258272553701889
Gr2_9_4 0 s9 x2_a4 0 -0.0012606483475327097
Gr3_re_9_4 0 s9 x3_re_a4 0 4550.0173476027785
Gr3_im_9_4 0 s9 x3_im_a4 0 -5923.173829702777
Gr4_9_4 0 s9 x4_a4 0 -0.2988186405595943
Gr5_9_4 0 s9 x5_a4 0 -0.005975170198399016
Gd9_5 0 s9 p5 0 -0.00018377222723227313
Fd9_5 0 s9 V5 -0.009188611361613657
Gr1_9_5 0 s9 x1_a5 0 0.016046132928812778
Gr2_9_5 0 s9 x2_a5 0 -0.007676861523684613
Gr3_re_9_5 0 s9 x3_re_a5 0 -3918.980263223388
Gr3_im_9_5 0 s9 x3_im_a5 0 2691.0206159827594
Gr4_9_5 0 s9 x4_a5 0 0.24275593565158454
Gr5_9_5 0 s9 x5_a5 0 0.007684550955455804
Gd9_6 0 s9 p6 0 -0.0005594868433461105
Fd9_6 0 s9 V6 -0.027974342167305526
Gr1_9_6 0 s9 x1_a6 0 -0.5343766817428495
Gr2_9_6 0 s9 x2_a6 0 0.35028316594988596
Gr3_re_9_6 0 s9 x3_re_a6 0 82369.11179873155
Gr3_im_9_6 0 s9 x3_im_a6 0 42543.36371226981
Gr4_9_6 0 s9 x4_a6 0 0.2357107556834641
Gr5_9_6 0 s9 x5_a6 0 -0.13873101904371732
Gd9_7 0 s9 p7 0 0.003570827888141622
Fd9_7 0 s9 V7 0.1785413944070811
Gr1_9_7 0 s9 x1_a7 0 0.17848959209343954
Gr2_9_7 0 s9 x2_a7 0 -0.21752522032548344
Gr3_re_9_7 0 s9 x3_re_a7 0 -79623.37256412982
Gr3_im_9_7 0 s9 x3_im_a7 0 -43870.65921990451
Gr4_9_7 0 s9 x4_a7 0 -0.23584373984037932
Gr5_9_7 0 s9 x5_a7 0 0.10814701588518319
Gd9_8 0 s9 p8 0 0.0032125943570826643
Fd9_8 0 s9 V8 0.16062971785413324
Gr1_9_8 0 s9 x1_a8 0 0.8093926343197247
Gr2_9_8 0 s9 x2_a8 0 -0.5454243792022084
Gr3_re_9_8 0 s9 x3_re_a8 0 -117896.64525540557
Gr3_im_9_8 0 s9 x3_im_a8 0 -72410.95656436798
Gr4_9_8 0 s9 x4_a8 0 -0.3644019881328484
Gr5_9_8 0 s9 x5_a8 0 0.21632055491657406
Gd9_9 0 s9 p9 0 0.00581865470331259
Fd9_9 0 s9 V9 0.2909327351656295
Gr1_9_9 0 s9 x1_a9 0 0.09590552840181209
Gr2_9_9 0 s9 x2_a9 0 0.17163444219517776
Gr3_re_9_9 0 s9 x3_re_a9 0 119201.93880929156
Gr3_im_9_9 0 s9 x3_im_a9 0 69070.1668921601
Gr4_9_9 0 s9 x4_a9 0 0.36486326195610586
Gr5_9_9 0 s9 x5_a9 0 -0.13337951564732553
Gd9_10 0 s9 p10 0 0.0002716145226268509
Fd9_10 0 s9 V10 0.013580726131342548
Gr1_9_10 0 s9 x1_a10 0 -0.029538883657648528
Gr2_9_10 0 s9 x2_a10 0 0.015285621427118522
Gr3_re_9_10 0 s9 x3_re_a10 0 9291.462319686483
Gr3_im_9_10 0 s9 x3_im_a10 0 -3350.568086970334
Gr4_9_10 0 s9 x4_a10 0 -0.4680186204125658
Gr5_9_10 0 s9 x5_a10 0 0.0025079483683142605
Gd9_11 0 s9 p11 0 -9.11362787171332e-05
Fd9_11 0 s9 V11 -0.004556813935856659
Gr1_9_11 0 s9 x1_a11 0 0.00017433364684344384
Gr2_9_11 0 s9 x2_a11 0 0.006255466093992181
Gr3_re_9_11 0 s9 x3_re_a11 0 -6113.289065960523
Gr3_im_9_11 0 s9 x3_im_a11 0 7462.205905038584
Gr4_9_11 0 s9 x4_a11 0 0.35068008524587657
Gr5_9_11 0 s9 x5_a11 0 0.0019273356538530417
Gd9_12 0 s9 p12 0 -3.449780374133042e-05
Fd9_12 0 s9 V12 -0.0017248901870665209
Gr1_9_12 0 s9 x1_a12 0 -0.003268972532902992
Gr2_9_12 0 s9 x2_a12 0 0.006824855453091795
Gr3_re_9_12 0 s9 x3_re_a12 0 -1273.1811228446643
Gr3_im_9_12 0 s9 x3_im_a12 0 4397.015812451072
Gr4_9_12 0 s9 x4_a12 0 0.3115785863883798
Gr5_9_12 0 s9 x5_a12 0 -0.007617048056678976
Gd9_13 0 s9 p13 0 0.0028637178496592934
Fd9_13 0 s9 V13 0.14318589248296468
Gr1_9_13 0 s9 x1_a13 0 0.3774640022963502
Gr2_9_13 0 s9 x2_a13 0 -0.3057352375138631
Gr3_re_9_13 0 s9 x3_re_a13 0 -96040.83359237856
Gr3_im_9_13 0 s9 x3_im_a13 0 -49856.99644935866
Gr4_9_13 0 s9 x4_a13 0 -0.27871775488254813
Gr5_9_13 0 s9 x5_a13 0 0.13984319409460194
Gd9_14 0 s9 p14 0 0.0010594770617630813
Fd9_14 0 s9 V14 0.05297385308815406
Gr1_9_14 0 s9 x1_a14 0 -0.6843497292939075
Gr2_9_14 0 s9 x2_a14 0 0.4297562999785615
Gr3_re_9_14 0 s9 x3_re_a14 0 99854.9399821018
Gr3_im_9_14 0 s9 x3_im_a14 0 47628.17725328456
Gr4_9_14 0 s9 x4_a14 0 0.2785613058518524
Gr5_9_14 0 s9 x5_a14 0 -0.16806277817394033
Gd9_15 0 s9 p15 0 0.00016953082820695737
Fd9_15 0 s9 V15 0.00847654141034787
Gr1_9_15 0 s9 x1_a15 0 0.48223982805306936
Gr2_9_15 0 s9 x2_a15 0 -0.35497546431949745
Gr3_re_9_15 0 s9 x3_re_a15 0 -81106.57611911328
Gr3_im_9_15 0 s9 x3_im_a15 0 -44058.695109160006
Gr4_9_15 0 s9 x4_a15 0 -0.235526189641244
Gr5_9_15 0 s9 x5_a15 0 0.1438164526383128
Cx1_a9 x1_a9 0 1.5871725736917026e-13
Gx1_a9 0 x1_a9 p9 0 0.016187839923618174
Fx1_a9 0 x1_a9 V9 0.8093919961809087
Rp1_a9 0 x1_a9 1.0 noisy=0
Cx2_a9 x2_a9 0 3.688153046977837e-13
Gx2_a9 0 x2_a9 p9 0 0.010908476772642884
Fx2_a9 0 x2_a9 V9 0.5454238386321443
Rp2_a9 0 x2_a9 1.0 noisy=0
Cx3_re_a9 x3_re_a9 0 2.3135888003926714e-12
Gx3_re_a9 0 x3_re_a9 p9 0 1.06225210362638e-08
Fx3_re_a9 0 x3_re_a9 V9 5.3112605181319e-07
Rp3_re_re_a9 0 x3_re_a9 1.0 noisy=0
Gp3_re_im_a9 0 x3_re_a9 x3_im_a9 0 2.9111243944429863
Cx3_im_a9 x3_im_a9 0 2.3135888003926714e-12
Gp3_im_re_a9 0 x3_im_a9 x3_re_a9 0 -2.9111243944429863
Rp3_im_im_a9 0 x3_im_a9 1.0 noisy=0
Cx4_a9 x4_a9 0 1.3081951314894418e-11
Gx4_a9 0 x4_a9 p9 0 0.011930371285505446
Fx4_a9 0 x4_a9 V9 0.5965185642752723
Rp4_a9 0 x4_a9 1.0 noisy=0
Cx5_a9 x5_a9 0 8.108684533816161e-13
Gx5_a9 0 x5_a9 p9 0 0.004326408842126095
Fx5_a9 0 x5_a9 V9 0.21632044210630477
Rp5_a9 0 x5_a9 1.0 noisy=0
V10 p10 s10 0.0
R10 s10 0 50.0 noisy=0
Gd10_1 0 s10 p1 0 0.004194358657831555
Fd10_1 0 s10 V1 0.2097179328915778
Gr1_10_1 0 s10 x1_a1 0 -0.06313848649478485
Gr2_10_1 0 s10 x2_a1 0 -0.37792186345726286
Gr3_re_10_1 0 s10 x3_re_a1 0 -24227.263327989145
Gr3_im_10_1 0 s10 x3_im_a1 0 11032.086019009406
Gr4_10_1 0 s10 x4_a1 0 0.5692110032598974
Gr5_10_1 0 s10 x5_a1 0 -0.17471172485980346
Gd10_2 0 s10 p2 0 0.0005955535322409517
Fd10_2 0 s10 V2 0.029777676612047586
Gr1_10_2 0 s10 x1_a2 0 -0.04786449456632408
Gr2_10_2 0 s10 x2_a2 0 0.12210626361761898
Gr3_re_10_2 0 s10 x3_re_a2 0 -12123.559830695836
Gr3_im_10_2 0 s10 x3_im_a2 0 -11045.7495182493
Gr4_10_2 0 s10 x4_a2 0 0.27892666355402396
Gr5_10_2 0 s10 x5_a2 0 -0.39834077762025355
Gd10_3 0 s10 p3 0 -0.0006981296167005796
Fd10_3 0 s10 V3 -0.03490648083502898
Gr1_10_3 0 s10 x1_a3 0 0.02747922324218476
Gr2_10_3 0 s10 x2_a3 0 0.05794650710196442
Gr3_re_10_3 0 s10 x3_re_a3 0 -5561.535815267224
Gr3_im_10_3 0 s10 x3_im_a3 0 -20992.21462550109
Gr4_10_3 0 s10 x4_a3 0 -0.2790185385490872
Gr5_10_3 0 s10 x5_a3 0 0.23030783518143477
Gd10_4 0 s10 p4 0 0.00207977583669245
Fd10_4 0 s10 V4 0.10398879183462251
Gr1_10_4 0 s10 x1_a4 0 -0.04370475617556046
Gr2_10_4 0 s10 x2_a4 0 -0.09736256213630086
Gr3_re_10_4 0 s10 x3_re_a4 0 -1525.8162890827991
Gr3_im_10_4 0 s10 x3_im_a4 0 11392.258420328937
Gr4_10_4 0 s10 x4_a4 0 0.485354231195167
Gr5_10_4 0 s10 x5_a4 0 -0.48698888351942216
Gd10_5 0 s10 p5 0 -0.0002839702749444949
Fd10_5 0 s10 V5 -0.014198513747224745
Gr1_10_5 0 s10 x1_a5 0 -0.020676947875472414
Gr2_10_5 0 s10 x2_a5 0 0.013518248006716265
Gr3_re_10_5 0 s10 x3_re_a5 0 10875.041074937535
Gr3_im_10_5 0 s10 x3_im_a5 0 22726.060732686186
Gr4_10_5 0 s10 x4_a5 0 -0.3940246169624178
Gr5_10_5 0 s10 x5_a5 0 0.42605361866306435
Gd10_6 0 s10 p6 0 0.00012419221808718974
Fd10_6 0 s10 V6 0.0062096109043594866
Gr1_10_6 0 s10 x1_a6 0 -0.012242496736618085
Gr2_10_6 0 s10 x2_a6 0 0.0038055138988613963
Gr3_re_10_6 0 s10 x3_re_a6 0 1777.040726089272
Gr3_im_10_6 0 s10 x3_im_a6 0 -1054.0181078658986
Gr4_10_6 0 s10 x4_a6 0 -0.3855680984157855
Gr5_10_6 0 s10 x5_a6 0 0.0053940579045535396
Gd10_7 0 s10 p7 0 -0.00010672767377865622
Fd10_7 0 s10 V7 -0.005336383688932811
Gr1_10_7 0 s10 x1_a7 0 0.014179032621049586
Gr2_10_7 0 s10 x2_a7 0 -0.013094348587718308
Gr3_re_10_7 0 s10 x3_re_a7 0 -1945.8521464080193
Gr3_im_10_7 0 s10 x3_im_a7 0 738.9027908106655
Gr4_10_7 0 s10 x4_a7 0 0.3854592126931566
Gr5_10_7 0 s10 x5_a7 0 -0.004409481289976202
Gd10_8 0 s10 p8 0 -0.0003485956999635416
Fd10_8 0 s10 V8 -0.017429784998177083
Gr1_10_8 0 s10 x1_a8 0 0.0521127190312083
Gr2_10_8 0 s10 x2_a8 0 -0.050134419252081064
Gr3_re_10_8 0 s10 x3_re_a8 0 -3194.322406379935
Gr3_im_10_8 0 s10 x3_im_a8 0 -709.1923652566626
Gr4_10_8 0 s10 x4_a8 0 0.5953710990134146
Gr5_10_8 0 s10 x5_a8 0 0.007278953107665676
Gd10_9 0 s10 p9 0 0.0002716145029361648
Fd10_9 0 s10 V9 0.013580725146808241
Gr1_10_9 0 s10 x1_a9 0 -0.030415661781814842
Gr2_10_9 0 s10 x2_a9 0 0.02136619405666253
Gr3_re_10_9 0 s10 x3_re_a9 0 2956.7488939989125
Gr3_im_10_9 0 s10 x3_im_a9 0 -1066.22932397151
Gr4_10_9 0 s10 x4_a9 0 -0.5965185642752723
Gr5_10_9 0 s10 x5_a9 0 0.007141635547701983
Gd10_10 0 s10 p10 0 -0.014160523040771903
Fd10_10 0 s10 V10 -0.7080261520385952
Gr1_10_10 0 s10 x1_a10 0 0.4339861197259704
Gr2_10_10 0 s10 x2_a10 0 0.22635930776708754
Gr3_re_10_10 0 s10 x3_re_a10 0 -80.05669060746864
Gr3_im_10_10 0 s10 x3_im_a10 0 -4735.353702781318
Gr4_10_10 0 s10 x4_a10 0 0.7602996554600222
Gr5_10_10 0 s10 x5_a10 0 0.39290428174917147
Gd10_11 0 s10 p11 0 -0.00035261501262638976
Fd10_11 0 s10 V11 -0.01763075063131949
Gr1_10_11 0 s10 x1_a11 0 0.8334174740784239
Gr2_10_11 0 s10 x2_a11 0 -0.4246290088858653
Gr3_re_10_11 0 s10 x3_re_a11 0 -11137.631169352198
Gr3_im_10_11 0 s10 x3_im_a11 0 -6526.605804855068
Gr4_10_11 0 s10 x4_a11 0 -0.5682802132293461
Gr5_10_11 0 s10 x5_a11 0 0.43786623258771445
Gd10_12 0 s10 p12 0 0.0024948559101361655
Fd10_12 0 s10 V12 0.12474279550680828
Gr1_10_12 0 s10 x1_a12 0 0.7297691629831118
Gr2_10_12 0 s10 x2_a12 0 0.11386695500912397
Gr3_re_10_12 0 s10 x3_re_a12 0 -1512.6415858710031
Gr3_im_10_12 0 s10 x3_im_a12 0 19734.343052520926
Gr4_10_12 0 s10 x4_a12 0 -0.5056388945295935
Gr5_10_12 0 s10 x5_a12 0 -0.5119468184268546
Gd10_13 0 s10 p13 0 -0.0001598994457415625
Fd10_13 0 s10 V13 -0.007994972287078125
Gr1_10_13 0 s10 x1_a13 0 0.014778952435762742
Gr2_10_13 0 s10 x2_a13 0 -0.009729015433980451
Gr3_re_10_13 0 s10 x3_re_a13 0 -2117.5330589278897
Gr3_im_10_13 0 s10 x3_im_a13 0 926.1001441383837
Gr4_10_13 0 s10 x4_a13 0 0.4556847324004697
Gr5_10_13 0 s10 x5_a13 0 -0.006595854840598042
Gd10_14 0 s10 p14 0 0.00021045186420455192
Fd10_14 0 s10 V14 0.010522593210227596
Gr1_10_14 0 s10 x1_a14 0 -0.01210408233189416
Gr2_10_14 0 s10 x2_a14 0 0.0008430147511524615
Gr3_re_10_14 0 s10 x3_re_a14 0 1883.3772933107139
Gr3_im_10_14 0 s10 x3_im_a14 0 -1059.1213422525966
Gr4_10_14 0 s10 x4_a14 0 -0.45586708633965156
Gr5_10_14 0 s10 x5_a14 0 0.004761406820677557
Gd10_15 0 s10 p15 0 -0.00015389699484303414
Fd10_15 0 s10 V15 -0.007694849742151707
Gr1_10_15 0 s10 x1_a15 0 0.009933138740277014
Gr2_10_15 0 s10 x2_a15 0 0.0005411694583774803
Gr3_re_10_15 0 s10 x3_re_a15 0 -1664.3301890596056
Gr3_im_10_15 0 s10 x3_im_a15 0 1037.1564850862137
Gr4_10_15 0 s10 x4_a15 0 0.3852865222781068
Gr5_10_15 0 s10 x5_a15 0 -0.0036790399400904936
Cx1_a10 x1_a10 0 1.5871725736917026e-13
Gx1_a10 0 x1_a10 p10 0 0.016668340392031647
Fx1_a10 0 x1_a10 V10 0.8334170196015824
Rp1_a10 0 x1_a10 1.0 noisy=0
Cx2_a10 x2_a10 0 3.688153046977837e-13
Gx2_a10 0 x2_a10 p10 0 0.015247869655983622
Fx2_a10 0 x2_a10 V10 0.7623934827991812
Rp2_a10 0 x2_a10 1.0 noisy=0
Cx3_re_a10 x3_re_a10 0 2.3135888003926714e-12
Gx3_re_a10 0 x3_re_a10 p10 0 3.380311954218229e-09
Fx3_re_a10 0 x3_re_a10 V10 1.6901559771091147e-07
Rp3_re_re_a10 0 x3_re_a10 1.0 noisy=0
Gp3_re_im_a10 0 x3_re_a10 x3_im_a10 0 2.9111243944429863
Cx3_im_a10 x3_im_a10 0 2.3135888003926714e-12
Gp3_im_re_a10 0 x3_im_a10 x3_re_a10 0 -2.9111243944429863
Rp3_im_im_a10 0 x3_im_a10 1.0 noisy=0
Cx4_a10 x4_a10 0 1.3081951314894418e-11
Gx4_a10 0 x4_a10 p10 0 0.015205993109200441
Fx4_a10 0 x4_a10 V10 0.7602996554600221
Rp4_a10 0 x4_a10 1.0 noisy=0
Cx5_a10 x5_a10 0 8.108684533816161e-13
Gx5_a10 0 x5_a10 p10 0 0.01231979491641921
Fx5_a10 0 x5_a10 V10 0.6159897458209604
Rp5_a10 0 x5_a10 1.0 noisy=0
V11 p11 s11 0.0
R11 s11 0 50.0 noisy=0
Gd11_1 0 s11 p1 0 -0.00611551569274466
Fd11_1 0 s11 V1 -0.305775784637233
Gr1_11_1 0 s11 x1_a1 0 0.15725350578184882
Gr2_11_1 0 s11 x2_a1 0 0.5539148524560608
Gr3_re_11_1 0 s11 x3_re_a1 0 39522.150563109375
Gr3_im_11_1 0 s11 x3_im_a1 0 -22811.359405876494
Gr4_11_1 0 s11 x4_a1 0 -0.31786941435296306
Gr5_11_1 0 s11 x5_a1 0 -0.2071402299696763
Gd11_2 0 s11 p2 0 0.00018481184874369797
Fd11_2 0 s11 V2 0.009240592437184898
Gr1_11_2 0 s11 x1_a2 0 -0.04318942297419881
Gr2_11_2 0 s11 x2_a2 0 0.15099536103237807
Gr3_re_11_2 0 s11 x3_re_a2 0 -2123.2693081259413
Gr3_im_11_2 0 s11 x3_im_a2 0 2599.357746150183
Gr4_11_2 0 s11 x4_a2 0 -0.1583726840981832
Gr5_11_2 0 s11 x5_a2 0 -0.3530522906044136
Gd11_3 0 s11 p3 0 0.00020662465757031922
Fd11_3 0 s11 V3 0.01033123287851596
Gr1_11_3 0 s11 x1_a3 0 -0.052088173822374566
Gr2_11_3 0 s11 x2_a3 0 0.05374477323080323
Gr3_re_11_3 0 s11 x3_re_a3 0 360.91981941858046
Gr3_im_11_3 0 s11 x3_im_a3 0 -6346.075537646195
Gr4_11_3 0 s11 x4_a3 0 0.15694397126079057
Gr5_11_3 0 s11 x5_a3 0 0.1635819956265133
Gd11_4 0 s11 p4 0 0.00025142958810142006
Fd11_4 0 s11 V4 0.012571479405071005
Gr1_11_4 0 s11 x1_a4 0 0.07810833879978567
Gr2_11_4 0 s11 x2_a4 0 0.004666830405808656
Gr3_re_11_4 0 s11 x3_re_a4 0 -7615.273880269837
Gr3_im_11_4 0 s11 x3_im_a4 0 10334.938352119692
Gr4_11_4 0 s11 x4_a4 0 -0.2733607998044603
Gr5_11_4 0 s11 x5_a4 0 -0.40897012118606857
Gd11_5 0 s11 p5 0 4.7620178855267595e-06
Fd11_5 0 s11 V5 0.000238100894276338
Gr1_11_5 0 s11 x1_a5 0 -0.0385520551361284
Gr2_11_5 0 s11 x2_a5 0 -0.14852897762551118
Gr3_re_11_5 0 s11 x3_re_a5 0 5352.874122572239
Gr3_im_11_5 0 s11 x3_im_a5 0 -474.4027820516868
Gr4_11_5 0 s11 x4_a5 0 0.22212853676321503
Gr5_11_5 0 s11 x5_a5 0 0.37716454163157703
Gd11_6 0 s11 p6 0 3.9031760405422125e-06
Fd11_6 0 s11 V6 0.00019515880202711062
Gr1_11_6 0 s11 x1_a6 0 -0.006725287961260754
Gr2_11_6 0 s11 x2_a6 0 0.014035273120765558
Gr3_re_11_6 0 s11 x3_re_a6 0 -1476.0475734684696
Gr3_im_11_6 0 s11 x3_im_a6 0 2078.765036262677
Gr4_11_6 0 s11 x4_a6 0 0.21587020894483186
Gr5_11_6 0 s11 x5_a6 0 -0.003122018661055332
Gd11_7 0 s11 p7 0 2.3709986824916236e-05
Fd11_7 0 s11 V7 0.0011854993412458118
Gr1_11_7 0 s11 x1_a7 0 0.0004998479786590881
Gr2_11_7 0 s11 x2_a7 0 -0.00639548330135461
Gr3_re_11_7 0 s11 x3_re_a7 0 1653.743232970787
Gr3_im_11_7 0 s11 x3_im_a7 0 -2035.6130166863927
Gr4_11_7 0 s11 x4_a7 0 -0.2158694711000697
Gr5_11_7 0 s11 x5_a7 0 -0.0006503408744205958
Gd11_8 0 s11 p8 0 0.00016098667741318515
Fd11_8 0 s11 V8 0.008049333870659257
Gr1_11_8 0 s11 x1_a8 0 -0.012776844937521096
Gr2_11_8 0 s11 x2_a8 0 0.0029202504756769294
Gr3_re_11_8 0 s11 x3_re_a8 0 2566.5589395201505
Gr3_im_11_8 0 s11 x3_im_a8 0 -2023.584291165771
Gr4_11_8 0 s11 x4_a8 0 -0.3336816136466995
Gr5_11_8 0 s11 x5_a8 0 -0.011004626556434024
Gd11_9 0 s11 p9 0 -9.113417724886965e-05
Fd11_9 0 s11 V9 -0.0045567088624434825
Gr1_11_9 0 s11 x1_a9 0 0.00017920051033932697
Gr2_11_9 0 s11 x2_a9 0 0.010586166293044893
Gr3_re_11_9 0 s11 x3_re_a9 0 -2238.0586788253095
Gr3_im_11_9 0 s11 x3_im_a9 0 2731.944140307666
Gr4_11_9 0 s11 x4_a9 0 0.33407938017618133
Gr5_11_9 0 s11 x5_a9 0 0.004868252754846657
Gd11_10 0 s11 p10 0 -0.0003526087455911773
Fd11_10 0 s11 V10 -0.017630437279558864
Gr1_11_10 0 s11 x1_a10 0 0.8334170196015823
Gr2_11_10 0 s11 x2_a10 0 -0.5140795326982489
Gr3_re_11_10 0 s11 x3_re_a10 0 -12813.232463817476
Gr3_im_11_10 0 s11 x3_im_a10 0 -7508.434466408638
Gr4_11_10 0 s11 x4_a10 0 -0.42475673654377144
Gr5_11_10 0 s11 x5_a10 0 0.3884103804481235
Gd11_11 0 s11 p11 0 -0.01540528242403853
Fd11_11 0 s11 V11 -0.7702641212019266
Gr1_11_11 0 s11 x1_a11 0 0.6952331779528491
Gr2_11_11 0 s11 x2_a11 0 0.34646174400587665
Gr3_re_11_11 0 s11 x3_re_a11 0 -6055.374072260913
Gr3_im_11_11 0 s11 x3_im_a11 0 19215.320140294243
Gr4_11_11 0 s11 x4_a11 0 0.31723773749299067
Gr5_11_11 0 s11 x5_a11 0 0.2757951035853898
Gd11_12 0 s11 p12 0 0.0018355484941909189
Fd11_12 0 s11 V12 0.09177742470954595
Gr1_11_12 0 s11 x1_a12 0 0.8174194890266022
Gr2_11_12 0 s11 x2_a12 0 -0.46678371375437283
Gr3_re_11_12 0 s11 x3_re_a12 0 -25661.460727281104
Gr3_im_11_12 0 s11 x3_im_a12 0 2863.575587713424
Gr4_11_12 0 s11 x4_a12 0 0.28475200558421165
Gr5_11_12 0 s11 x5_a12 0 -0.3969611877777678
Gd11_13 0 s11 p13 0 5.5343787899978817e-05
Fd11_13 0 s11 V13 0.002767189394998941
Gr1_11_13 0 s11 x1_a13 0 0.0018426752024360844
Gr2_11_13 0 s11 x2_a13 0 -0.009953548350023222
Gr3_re_11_13 0 s11 x3_re_a13 0 1404.5841617866788
Gr3_im_11_13 0 s11 x3_im_a13 0 -1953.9495304047741
Gr4_11_13 0 s11 x4_a13 0 -0.2551870016744825
Gr5_11_13 0 s11 x5_a13 0 -0.004542939381043325
Gd11_14 0 s11 p14 0 -2.9171172676303922e-05
Fd11_14 0 s11 V14 -0.001458558633815196
Gr1_11_14 0 s11 x1_a14 0 -0.006931698818416609
Gr2_11_14 0 s11 x2_a14 0 0.017575813652908095
Gr3_re_11_14 0 s11 x3_re_a14 0 -1217.699225735674
Gr3_im_11_14 0 s11 x3_im_a14 0 1989.5130653650306
Gr4_11_14 0 s11 x4_a14 0 0.25524011734318547
Gr5_11_14 0 s11 x5_a14 0 -0.0004839126565305383
Gd11_15 0 s11 p15 0 -2.0204356697527047e-05
Fd11_15 0 s11 V15 -0.0010102178348763524
Gr1_11_15 0 s11 x1_a15 0 0.008543730171658213
Gr2_11_15 0 s11 x2_a15 0 -0.018004031295847846
Gr3_re_11_15 0 s11 x3_re_a15 0 1426.407875786527
Gr3_im_11_15 0 s11 x3_im_a15 0 -1965.460559079629
Gr4_11_15 0 s11 x4_a15 0 -0.21568816227274729
Gr5_11_15 0 s11 x5_a15 0 0.005878470819081752
Cx1_a11 x1_a11 0 1.5871725736917026e-13
Gx1_a11 0 x1_a11 p11 0 0.01666834948156848
Fx1_a11 0 x1_a11 V11 0.833417474078424
Rp1_a11 0 x1_a11 1.0 noisy=0
Cx2_a11 x2_a11 0 3.688153046977837e-13
Gx2_a11 0 x2_a11 p11 0 0.01845994576918211
Fx2_a11 0 x2_a11 V11 0.9229972884591054
Rp2_a11 0 x2_a11 1.0 noisy=0
Cx3_re_a11 x3_re_a11 0 2.3135888003926714e-12
Gx3_re_a11 0 x3_re_a11 p11 0 3.8889248395807165e-09
Fx3_re_a11 0 x3_re_a11 V11 1.9444624197903585e-07
Rp3_re_re_a11 0 x3_re_a11 1.0 noisy=0
Gp3_re_im_a11 0 x3_re_a11 x3_im_a11 0 2.9111243944429863
Cx3_im_a11 x3_im_a11 0 2.3135888003926714e-12
Gp3_im_re_a11 0 x3_im_a11 x3_re_a11 0 -2.9111243944429863
Rp3_im_im_a11 0 x3_im_a11 1.0 noisy=0
Cx4_a11 x4_a11 0 1.3081951314894418e-11
Gx4_a11 0 x4_a11 p11 0 0.011365604264586918
Fx4_a11 0 x4_a11 V11 0.568280213229346
Rp4_a11 0 x4_a11 1.0 noisy=0
Cx5_a11 x5_a11 0 8.108684533816161e-13
Gx5_a11 0 x5_a11 p11 0 0.010928310134061101
Fx5_a11 0 x5_a11 V11 0.546415506703055
Rp5_a11 0 x5_a11 1.0 noisy=0
V12 p12 s12 0.0
R12 s12 0 50.0 noisy=0
Gd12_1 0 s12 p1 0 0.0025232767037400316
Fd12_1 0 s12 V1 0.12616383518700158
Gr1_12_1 0 s12 x1_a1 0 -0.055583018103165634
Gr2_12_1 0 s12 x2_a1 0 -0.21935023617667831
Gr3_re_12_1 0 s12 x3_re_a1 0 -10188.431869849243
Gr3_im_12_1 0 s12 x3_im_a1 0 4065.089385518463
Gr4_12_1 0 s12 x4_a1 0 -0.2541335136591648
Gr5_12_1 0 s12 x5_a1 0 0.32143357556592006
Gd12_2 0 s12 p2 0 -0.0001986999273504442
Fd12_2 0 s12 V2 -0.00993499636752221
Gr1_12_2 0 s12 x1_a2 0 0.027086360229191028
Gr2_12_2 0 s12 x2_a2 0 -0.1628376542039489
Gr3_re_12_2 0 s12 x3_re_a2 0 13331.9332368386
Gr3_im_12_2 0 s12 x3_im_a2 0 359.9359722300461
Gr4_12_2 0 s12 x4_a2 0 -0.12199659145695714
Gr5_12_2 0 s12 x5_a2 0 0.6234059893557279
Gd12_3 0 s12 p3 0 0.001178931297478942
Fd12_3 0 s12 V3 0.0589465648739471
Gr1_12_3 0 s12 x1_a3 0 -0.10625875293751968
Gr2_12_3 0 s12 x2_a3 0 -0.05329150135533048
Gr3_re_12_3 0 s12 x3_re_a3 0 5062.271667375065
Gr3_im_12_3 0 s12 x3_im_a3 0 17166.34020576636
Gr4_12_3 0 s12 x4_a3 0 0.1219052725535344
Gr5_12_3 0 s12 x5_a3 0 -0.2966634623799913
Gd12_4 0 s12 p4 0 -0.0010788347572659
Fd12_4 0 s12 V4 -0.053941737863295
Gr1_12_4 0 s12 x1_a4 0 0.14359182030077058
Gr2_12_4 0 s12 x2_a4 0 -0.02875791909296914
Gr3_re_12_4 0 s12 x3_re_a4 0 5562.092779776725
Gr3_im_12_4 0 s12 x3_im_a4 0 -20536.273441320966
Gr4_12_4 0 s12 x4_a4 0 -0.21460105501301335
Gr5_12_4 0 s12 x5_a4 0 0.7300508109096842
Gd12_5 0 s12 p5 0 0.0016986804517874902
Fd12_5 0 s12 V5 0.08493402258937452
Gr1_12_5 0 s12 x1_a5 0 -0.1479372004204379
Gr2_12_5 0 s12 x2_a5 0 0.1486374928445422
Gr3_re_12_5 0 s12 x3_re_a5 0 -4695.2716640467
Gr3_im_12_5 0 s12 x3_im_a5 0 -10455.661158951048
Gr4_12_5 0 s12 x4_a5 0 0.17305519791832685
Gr5_12_5 0 s12 x5_a5 0 -0.6603806243504641
Gd12_6 0 s12 p6 0 9.510405686433337e-06
Fd12_6 0 s12 V6 0.0004755202843216669
Gr1_12_6 0 s12 x1_a6 0 -0.004014956640768431
Gr2_12_6 0 s12 x2_a6 0 0.001744326512814557
Gr3_re_12_6 0 s12 x3_re_a6 0 -9.98564892692106
Gr3_im_12_6 0 s12 x3_im_a6 0 646.5807011286431
Gr4_12_6 0 s12 x4_a6 0 0.17068384955011334
Gr5_12_6 0 s12 x5_a6 0 -0.009681934196100231
Gd12_7 0 s12 p7 0 3.4573376136799884e-05
Fd12_7 0 s12 V7 0.0017286688068399944
Gr1_12_7 0 s12 x1_a7 0 -0.0003763631475714264
Gr2_12_7 0 s12 x2_a7 0 -0.0019668169590190067
Gr3_re_12_7 0 s12 x3_re_a7 0 100.27405852224015
Gr3_im_12_7 0 s12 x3_im_a7 0 -485.7204784334497
Gr4_12_7 0 s12 x4_a7 0 -0.17067121557950532
Gr5_12_7 0 s12 x5_a7 0 0.013606254468764937
Gd12_8 0 s12 p8 0 0.0001167862881720067
Fd12_8 0 s12 V8 0.005839314408600335
Gr1_12_8 0 s12 x1_a8 0 -0.0058290411231521535
Gr2_12_8 0 s12 x2_a8 0 -0.0017105173804044024
Gr3_re_12_8 0 s12 x3_re_a8 0 553.6435394540669
Gr3_im_12_8 0 s12 x3_im_a8 0 -857.8817487651509
Gr4_12_8 0 s12 x4_a8 0 -0.2638030389645606
Gr5_12_8 0 s12 x5_a8 0 0.024698936250394942
Gd12_9 0 s12 p9 0 -3.449906214894164e-05
Fd12_9 0 s12 V9 -0.001724953107447082
Gr1_12_9 0 s12 x1_a9 0 -0.003301184934415616
Gr2_12_9 0 s12 x2_a9 0 0.007267625846754376
Gr3_re_12_9 0 s12 x3_re_a9 0 -351.5558376609847
Gr3_im_12_9 0 s12 x3_im_a9 0 1214.0704688816804
Gr4_12_9 0 s12 x4_a9 0 0.26410954956437427
Gr5_12_9 0 s12 x5_a9 0 -0.02609808249511996
Gd12_10 0 s12 p10 0 0.0024948757162525518
Fd12_10 0 s12 V10 0.1247437858126276
Gr1_12_10 0 s12 x1_a10 0 0.7157581057832343
Gr2_12_10 0 s12 x2_a10 0 0.08675204495011934
Gr3_re_12_10 0 s12 x3_re_a10 0 -1311.9964517059293
Gr3_im_12_10 0 s12 x3_im_a10 0 17124.158917889174
Gr4_12_10 0 s12 x4_a10 0 -0.33627620928208324
Gr5_12_10 0 s12 x5_a10 0 -0.6159897458209606
Gd12_11 0 s12 p11 0 0.0018355800341602734
Fd12_11 0 s12 V11 0.09177900170801367
Gr1_12_11 0 s12 x1_a11 0 0.8017239077268448
Gr2_12_11 0 s12 x2_a11 0 -0.29373721567235583
Gr3_re_12_11 0 s12 x3_re_a11 0 -19353.231790078364
Gr3_im_12_11 0 s12 x3_im_a11 0 2160.7207137238624
Gr4_12_11 0 s12 x4_a11 0 0.25336389188475444
Gr5_12_11 0 s12 x5_a11 0 -0.5384525499087603
Gd12_12 0 s12 p12 0 -0.015718627614770855
Fd12_12 0 s12 V12 -0.7859313807385429
Gr1_12_12 0 s12 x1_a12 0 0.7681788478462057
Gr2_12_12 0 s12 x2_a12 0 0.008748763606256788
Gr3_re_12_12 0 s12 x3_re_a12 0 -1963.919156937297
Gr3_im_12_12 0 s12 x3_im_a12 0 8381.619174824782
Gr4_12_12 0 s12 x4_a12 0 0.22363459856573303
Gr5_12_12 0 s12 x5_a12 0 0.7411765848320285
Gd12_13 0 s12 p13 0 -1.6290753743129226e-05
Fd12_13 0 s12 V13 -0.0008145376871564613
Gr1_12_13 0 s12 x1_a13 0 0.005026998628407815
Gr2_12_13 0 s12 x2_a13 0 -0.006997081904575129
Gr3_re_12_13 0 s12 x3_re_a13 0 315.3707478383819
Gr3_im_12_13 0 s12 x3_im_a13 0 -1227.3772799839833
Gr4_12_13 0 s12 x4_a13 0 -0.20173121529668697
Gr5_12_13 0 s12 x5_a13 0 0.02154327188007742
Gd12_14 0 s12 p14 0 9.700853135302337e-05
Fd12_14 0 s12 V14 0.004850426567651168
Gr1_12_14 0 s12 x1_a14 0 -0.011212249807850903
Gr2_12_14 0 s12 x2_a14 0 0.006539082098608053
Gr3_re_12_14 0 s12 x3_re_a14 0 -191.20640034804308
Gr3_im_12_14 0 s12 x3_im_a14 0 1369.57492782739
Gr4_12_14 0 s12 x4_a14 0 0.20179278764518013
Gr5_12_14 0 s12 x5_a14 0 -0.014736605720205574
Gd12_15 0 s12 p15 0 -3.589016054768538e-05
Fd12_15 0 s12 V15 -0.001794508027384269
Gr1_12_15 0 s12 x1_a15 0 0.004704050638405335
Gr2_12_15 0 s12 x2_a15 0 0.0006519584837706557
Gr3_re_12_15 0 s12 x3_re_a15 0 59.15772957755332
Gr3_im_12_15 0 s12 x3_im_a15 0 -645.4512409367784
Gr4_12_15 0 s12 x4_a15 0 -0.1705452572531224
Gr5_12_15 0 s12 x5_a15 0 0.004960370650426406
Cx1_a12 x1_a12 0 1.5871725736917026e-13
Gx1_a12 0 x1_a12 p12 0 0.016348389780532047
Fx1_a12 0 x1_a12 V12 0.8174194890266023
Rp1_a12 0 x1_a12 1.0 noisy=0
Cx2_a12 x2_a12 0 3.688153046977837e-13
Gx2_a12 0 x2_a12 p12 0 0.011616579745660511
Fx2_a12 0 x2_a12 V12 0.5808289872830257
Rp2_a12 0 x2_a12 1.0 noisy=0
Cx3_re_a12 x3_re_a12 0 2.3135888003926714e-12
Gx3_re_a12 0 x3_re_a12 p12 0 2.9330608045223346e-09
Fx3_re_a12 0 x3_re_a12 V12 1.4665304022611674e-07
Rp3_re_re_a12 0 x3_re_a12 1.0 noisy=0
Gp3_re_im_a12 0 x3_re_a12 x3_im_a12 0 2.9111243944429863
Cx3_im_a12 x3_im_a12 0 2.3135888003926714e-12
Gp3_im_re_a12 0 x3_im_a12 x3_re_a12 0 -2.9111243944429863
Rp3_im_im_a12 0 x3_im_a12 1.0 noisy=0
Cx4_a12 x4_a12 0 1.3081951314894418e-11
Gx4_a12 0 x4_a12 p12 0 0.01011277789059187
Fx4_a12 0 x4_a12 V12 0.5056388945295935
Rp4_a12 0 x4_a12 1.0 noisy=0
Cx5_a12 x5_a12 0 8.108684533816161e-13
Gx5_a12 0 x5_a12 p12 0 0.014823531696640569
Fx5_a12 0 x5_a12 V12 0.7411765848320284
Rp5_a12 0 x5_a12 1.0 noisy=0
V13 p13 s13 0.0
R13 s13 0 50.0 noisy=0
Gd13_1 0 s13 p1 0 -8.440522690651298e-05
Fd13_1 0 s13 V1 -0.0042202613453256495
Gr1_13_1 0 s13 x1_a1 0 0.0003640181199640754
Gr2_13_1 0 s13 x2_a1 0 0.0031718413668656857
Gr3_re_13_1 0 s13 x3_re_a1 0 -2347.1574907637673
Gr3_im_13_1 0 s13 x3_im_a1 0 3986.6778739088068
Gr4_13_1 0 s13 x4_a1 0 0.2050809676310723
Gr5_13_1 0 s13 x5_a1 0 -0.0016946848653337286
Gd13_2 0 s13 p2 0 3.2071926157402674e-05
Fd13_2 0 s13 V2 0.0016035963078701338
Gr1_13_2 0 s13 x1_a2 0 -0.0010882909731798353
Gr2_13_2 0 s13 x2_a2 0 -0.0003178226798324167
Gr3_re_13_2 0 s13 x3_re_a2 0 -794.0929047549118
Gr3_im_13_2 0 s13 x3_im_a2 0 1465.6272099551547
Gr4_13_2 0 s13 x4_a2 0 0.10078889595837642
Gr5_13_2 0 s13 x5_a2 0 0.00330342618501152
Gd13_3 0 s13 p3 0 1.5786656466931255e-05
Fd13_3 0 s13 V3 0.0007893328233465628
Gr1_13_3 0 s13 x1_a3 0 -0.0015792250566209227
Gr2_13_3 0 s13 x2_a3 0 -0.0009523520762473888
Gr3_re_13_3 0 s13 x3_re_a3 0 981.4157932522903
Gr3_im_13_3 0 s13 x3_im_a3 0 -1433.7527307814369
Gr4_13_3 0 s13 x4_a3 0 -0.10013603087219451
Gr5_13_3 0 s13 x5_a3 0 0.0008013667582304385
Gd13_4 0 s13 p4 0 -6.177091259286586e-05
Fd13_4 0 s13 V4 -0.003088545629643293
Gr1_13_4 0 s13 x1_a4 0 0.00298083173664003
Gr2_13_4 0 s13 x2_a4 0 0.0018542698320529359
Gr3_re_13_4 0 s13 x3_re_a4 0 -2866.9196784384144
Gr3_im_13_4 0 s13 x3_im_a4 0 3984.5818026938055
Gr4_13_4 0 s13 x4_a4 0 0.17435865123591515
Gr5_13_4 0 s13 x5_a4 0 0.0029681216935644734
Gd13_5 0 s13 p5 0 8.461786737466197e-05
Fd13_5 0 s13 V5 0.004230893368733098
Gr1_13_5 0 s13 x1_a5 0 -0.008215840334593978
Gr2_13_5 0 s13 x2_a5 0 0.004960068160972961
Gr3_re_13_5 0 s13 x3_re_a5 0 2273.872526147158
Gr3_im_13_5 0 s13 x3_im_a5 0 -1579.6263477249058
Gr4_13_5 0 s13 x4_a5 0 -0.14165942853060157
Gr5_13_5 0 s13 x5_a5 0 -0.004471783938345467
Gd13_6 0 s13 p6 0 -0.0016462215796544197
Fd13_6 0 s13 V6 -0.082311078982721
Gr1_13_6 0 s13 x1_a6 0 -0.3028596949497432
Gr2_13_6 0 s13 x2_a6 0 0.04778102570704365
Gr3_re_13_6 0 s13 x3_re_a6 0 -43160.366693650794
Gr3_im_13_6 0 s13 x3_im_a6 0 -24236.202675156634
Gr4_13_6 0 s13 x4_a6 0 -0.13778223910634466
Gr5_13_6 0 s13 x5_a6 0 0.020245300874828374
Gd13_7 0 s13 p7 0 0.0046309930330059364
Fd13_7 0 s13 V7 0.23154965165029684
Gr1_13_7 0 s13 x1_a7 0 -0.012249286950198106
Gr2_13_7 0 s13 x2_a7 0 0.07074614109204122
Gr3_re_13_7 0 s13 x3_re_a7 0 44916.19055308079
Gr3_im_13_7 0 s13 x3_im_a7 0 23795.708010882958
Gr4_13_7 0 s13 x4_a7 0 0.13756327177181404
Gr5_13_7 0 s13 x5_a7 0 -0.04993040622505776
Gd13_8 0 s13 p8 0 -9.999347986038357e-05
Fd13_8 0 s13 V8 -0.004999673993019179
Gr1_13_8 0 s13 x1_a8 0 -0.60168389526954
Gr2_13_8 0 s13 x2_a8 0 0.3491188665501732
Gr3_re_13_8 0 s13 x3_re_a8 0 70331.7653430305
Gr3_im_13_8 0 s13 x3_im_a8 0 40053.035201518745
Gr4_13_8 0 s13 x4_a8 0 0.21258213238404486
Gr5_13_8 0 s13 x5_a8 0 -0.13035930816392796
Gd13_9 0 s13 p9 0 0.002863719284087339
Fd13_9 0 s13 V9 0.14318596420436697
Gr1_13_9 0 s13 x1_a9 0 0.37872678185124703
Gr2_13_9 0 s13 x2_a9 0 -0.26097920440442113
Gr3_re_13_9 0 s13 x3_re_a9 0 -73075.69229890313
Gr3_im_13_9 0 s13 x3_im_a9 0 -37935.31428848157
Gr4_13_9 0 s13 x4_a9 0 -0.21291446786093599
Gr5_13_9 0 s13 x5_a9 0 0.1085586779042587
Gd13_10 0 s13 p10 0 -0.00015989953447323983
Fd13_10 0 s13 V10 -0.007994976723661992
Gr1_13_10 0 s13 x1_a10 0 0.014400883226117829
Gr2_13_10 0 s13 x2_a10 0 -0.0059412152767854155
Gr3_re_13_10 0 s13 x3_re_a10 0 -5063.19236663119
Gr3_im_13_10 0 s13 x3_im_a10 0 2214.4601648019775
Gr4_13_10 0 s13 x4_a10 0 0.2731141273967674
Gr5_13_10 0 s13 x5_a10 0 -0.0017981756380854523
Gd13_11 0 s13 p11 0 5.534739389802941e-05
Fd13_11 0 s13 V11 0.0027673696949014706
Gr1_13_11 0 s13 x1_a11 0 0.001794932340556219
Gr2_13_11 0 s13 x2_a11 0 -0.005020317238387697
Gr3_re_13_11 0 s13 x3_re_a11 0 2919.227242016064
Gr3_im_13_11 0 s13 x3_im_a11 0 -4060.7396762252624
Gr4_13_11 0 s13 x4_a11 0 -0.2046258449542746
Gr5_13_11 0 s13 x5_a11 0 -0.0013963334154309126
Gd13_12 0 s13 p12 0 -1.629027109004488e-05
Fd13_12 0 s13 V12 -0.0008145135545022441
Gr1_13_12 0 s13 x1_a12 0 0.004994157254182625
Gr2_13_12 0 s13 x2_a12 0 -0.005608506253533157
Gr3_re_13_12 0 s13 x3_re_a12 0 869.0155884552848
Gr3_im_13_12 0 s13 x3_im_a12 0 -3382.0899817065992
Gr4_13_12 0 s13 x4_a12 0 -0.18180135184784307
Gr5_13_12 0 s13 x5_a12 0 0.00488096971939086
Gd13_13 0 s13 p13 0 0.004928565633771501
Fd13_13 0 s13 V13 0.24642828168857503
Gr1_13_13 0 s13 x1_a13 0 0.24771219671551953
Gr2_13_13 0 s13 x2_a13 0 -0.03323801142316571
Gr3_re_13_13 0 s13 x3_re_a13 0 53891.072868363735
Gr3_im_13_13 0 s13 x3_im_a13 0 28971.47941331436
Gr4_13_13 0 s13 x4_a13 0 0.16254709025221895
Gr5_13_13 0 s13 x5_a13 0 -0.039456430150037844
Gd13_14 0 s13 p14 0 0.0021138409036419305
Fd13_14 0 s13 V14 0.10569204518209653
Gr1_13_14 0 s13 x1_a14 0 0.8121004141206911
Gr2_13_14 0 s13 x2_a14 0 -0.4655806733199007
Gr3_re_13_14 0 s13 x3_re_a14 0 -64318.37322845573
Gr3_im_13_14 0 s13 x3_im_a14 0 -26598.021700902136
Gr4_13_14 0 s13 x4_a14 0 -0.16235547421732016
Gr5_13_14 0 s13 x5_a14 0 0.15652318716346778
Gd13_15 0 s13 p15 0 0.0012278836217699445
Fd13_15 0 s13 V15 0.06139418108849723
Gr1_13_15 0 s13 x1_a15 0 0.2923789511565758
Gr2_13_15 0 s13 x2_a15 0 -0.06666390995166722
Gr3_re_13_15 0 s13 x3_re_a15 0 41367.194791624184
Gr3_im_13_15 0 s13 x3_im_a15 0 25003.203844835072
Gr4_13_15 0 s13 x4_a15 0 0.13769070049947787
Gr5_13_15 0 s13 x5_a15 0 -0.013762912032971262
Cx1_a13 x1_a13 0 1.5871725736917026e-13
Gx1_a13 0 x1_a13 p13 0 0.01624200118989086
Fx1_a13 0 x1_a13 V13 0.812100059494543
Rp1_a13 0 x1_a13 1.0 noisy=0
Cx2_a13 x2_a13 0 3.688153046977837e-13
Gx2_a13 0 x2_a13 p13 0 0.00931160491460381
Fx2_a13 0 x2_a13 V13 0.4655802457301906
Rp2_a13 0 x2_a13 1.0 noisy=0
Cx3_re_a13 x3_re_a13 0 2.3135888003926714e-12
Gx3_re_a13 0 x3_re_a13 p13 0 8.082485229964995e-09
Fx3_re_a13 0 x3_re_a13 V13 4.041242614982497e-07
Rp3_re_re_a13 0 x3_re_a13 1.0 noisy=0
Gp3_re_im_a13 0 x3_re_a13 x3_im_a13 0 2.9111243944429863
Cx3_im_a13 x3_im_a13 0 2.3135888003926714e-12
Gp3_im_re_a13 0 x3_im_a13 x3_re_a13 0 -2.9111243944429863
Rp3_im_im_a13 0 x3_im_a13 1.0 noisy=0
Cx4_a13 x4_a13 0 1.3081951314894418e-11
Gx4_a13 0 x4_a13 p13 0 0.009113694648009393
Fx4_a13 0 x4_a13 V13 0.4556847324004697
Rp4_a13 0 x4_a13 1.0 noisy=0
Cx5_a13 x5_a13 0 8.108684533816161e-13
Gx5_a13 0 x5_a13 p13 0 0.0033585376527453066
Fx5_a13 0 x5_a13 V13 0.16792688263726532
Rp5_a13 0 x5_a13 1.0 noisy=0
V14 p14 s14 0.0
R14 s14 0 50.0 noisy=0
Gd14_1 0 s14 p1 0 0.00012842623230229416
Fd14_1 0 s14 V1 0.006421311615114708
Gr1_14_1 0 s14 x1_a1 0 -0.007868714168304161
Gr2_14_1 0 s14 x2_a1 0 0.003210992014740975
Gr3_re_14_1 0 s14 x3_re_a1 0 3091.411459351184
Gr3_im_14_1 0 s14 x3_im_a1 0 -3929.538151720101
Gr4_14_1 0 s14 x4_a1 0 -0.20517343361583598
Gr5_14_1 0 s14 x5_a1 0 0.0002368138196145311
Gd14_2 0 s14 p2 0 -1.2510107907602842e-05
Fd14_2 0 s14 V2 -0.0006255053953801422
Gr1_14_2 0 s14 x1_a2 0 -0.002618824887432259
Gr2_14_2 0 s14 x2_a2 0 0.003287771883372778
Gr3_re_14_2 0 s14 x3_re_a2 0 765.8298315563687
Gr3_im_14_2 0 s14 x3_im_a2 0 -1583.448861005518
Gr4_14_2 0 s14 x4_a2 0 -0.10079031275793193
Gr5_14_2 0 s14 x5_a2 0 -0.00172348783177045
Gd14_3 0 s14 p3 0 3.209338286159262e-05
Fd14_3 0 s14 V3 0.0016046691430796312
Gr1_14_3 0 s14 x1_a3 0 -0.0025308855712299415
Gr2_14_3 0 s14 x2_a3 0 0.002356810928430272
Gr3_re_14_3 0 s14 x3_re_a3 0 -1055.9587674395482
Gr3_im_14_3 0 s14 x3_im_a3 0 1087.3353494242863
Gr4_14_3 0 s14 x4_a3 0 0.10017184001521603
Gr5_14_3 0 s14 x5_a3 0 -0.00048368859028575996
Gd14_4 0 s14 p4 0 0.00010836538399982712
Fd14_4 0 s14 V4 0.005418269199991356
Gr1_14_4 0 s14 x1_a4 0 -0.004737717156036605
Gr2_14_4 0 s14 x2_a4 0 -0.003497706192305801
Gr3_re_14_4 0 s14 x3_re_a4 0 2844.3724033823637
Gr3_im_14_4 0 s14 x3_im_a4 0 -3805.94261185672
Gr4_14_4 0 s14 x4_a4 0 -0.1744664522187926
Gr5_14_4 0 s14 x5_a4 0 -0.0015253802946629284
Gd14_5 0 s14 p5 0 -8.691273243732188e-06
Fd14_5 0 s14 V5 -0.00043456366218660937
Gr1_14_5 0 s14 x1_a5 0 0.006491358256656458
Gr2_14_5 0 s14 x2_a5 0 -0.0078699698748414
Gr3_re_14_5 0 s14 x3_re_a5 0 -2277.601447121435
Gr3_im_14_5 0 s14 x3_im_a5 0 1641.1440034380707
Gr4_14_5 0 s14 x4_a5 0 0.14168943449516638
Gr5_14_5 0 s14 x5_a5 0 0.0032399377695460493
Gd14_6 0 s14 p6 0 4.8645780458057264e-05
Fd14_6 0 s14 V6 0.0024322890229028634
Gr1_14_6 0 s14 x1_a6 0 0.4704967060277529
Gr2_14_6 0 s14 x2_a6 0 -0.10827051817290592
Gr3_re_14_6 0 s14 x3_re_a6 0 40483.214926369576
Gr3_im_14_6 0 s14 x3_im_a6 0 23776.854426990405
Gr4_14_6 0 s14 x4_a6 0 0.13803677608203696
Gr5_14_6 0 s14 x5_a6 0 -0.008259579785222343
Gd14_7 0 s14 p7 0 -0.0011069259114350628
Fd14_7 0 s14 V7 -0.05534629557175314
Gr1_14_7 0 s14 x1_a7 0 -0.307525727097712
Gr2_14_7 0 s14 x2_a7 0 0.08146666285014292
Gr3_re_14_7 0 s14 x3_re_a7 0 -42461.3455693057
Gr3_im_14_7 0 s14 x3_im_a7 0 -23755.81535657679
Gr4_14_7 0 s14 x4_a7 0 -0.13780479776379842
Gr5_14_7 0 s14 x5_a7 0 0.008620247324355854
Gd14_8 0 s14 p8 0 -0.00170296926196768
Fd14_8 0 s14 V8 -0.085148463098384
Gr1_14_8 0 s14 x1_a8 0 0.7367015681571442
Gr2_14_8 0 s14 x2_a8 0 -0.3850074090176586
Gr3_re_14_8 0 s14 x3_re_a8 0 -73327.80671798514
Gr3_im_14_8 0 s14 x3_im_a8 0 -38578.499736134785
Gr4_14_8 0 s14 x4_a8 0 -0.2125606745485254
Gr5_14_8 0 s14 x5_a8 0 0.13367414540309058
Gd14_9 0 s14 p9 0 0.0010594815834621362
Fd14_9 0 s14 V9 0.05297407917310681
Gr1_14_9 0 s14 x1_a9 0 -0.6866402175319645
Gr2_14_9 0 s14 x2_a9 0 0.36684561219438955
Gr3_re_14_9 0 s14 x3_re_a9 0 76014.26215767753
Gr3_im_14_9 0 s14 x3_im_a9 0 36256.688761613055
Gr4_14_9 0 s14 x4_a9 0 0.2128800892727154
Gr5_14_9 0 s14 x5_a9 0 -0.132112997835296
Gd14_10 0 s14 p10 0 0.00021045143910200864
Fd14_10 0 s14 V10 0.010522571955100432
Gr1_14_10 0 s14 x1_a10 0 -0.011794437492857518
Gr2_14_10 0 s14 x2_a10 0 0.0005147829457786936
Gr3_re_14_10 0 s14 x3_re_a10 0 4505.366898655453
Gr3_im_14_10 0 s14 x3_im_a10 0 -2533.620025208412
Gr4_14_10 0 s14 x4_a10 0 -0.2733327552501724
Gr5_14_10 0 s14 x5_a10 0 0.0013144203435024187
Gd14_11 0 s14 p11 0 -2.917276950041691e-05
Fd14_11 0 s14 V11 -0.0014586384750208455
Gr1_14_11 0 s14 x1_a11 0 -0.006754167358473437
Gr2_14_11 0 s14 x2_a11 0 0.008865486965856846
Gr3_re_14_11 0 s14 x3_re_a11 0 -2532.043620003448
Gr3_im_14_11 0 s14 x3_im_a11 0 4136.807109638421
Gr4_14_11 0 s14 x4_a11 0 0.20475034255863983
Gr5_14_11 0 s14 x5_a11 0 -0.00015055548429103837
Gd14_12 0 s14 p12 0 9.700768360465388e-05
Fd14_12 0 s14 V12 0.004850384180232694
Gr1_14_12 0 s14 x1_a12 0 -0.011139166847512946
Gr2_14_12 0 s14 x2_a12 0 0.005241477314615576
Gr3_re_14_12 0 s14 x3_re_a12 0 -527.1911547256566
Gr3_im_14_12 0 s14 x3_im_a12 0 3775.8443064924227
Gr4_14_12 0 s14 x4_a12 0 0.18192961767233912
Gr5_14_12 0 s14 x5_a12 0 -0.0033810098051104275
Gd14_13 0 s14 p13 0 0.002113845738468532
Fd14_13 0 s14 V13 0.10569228692342661
Gr1_14_13 0 s14 x1_a13 0 0.812100059494543
Gr2_14_13 0 s14 x2_a13 0 -0.46558024573019063
Gr3_re_14_13 0 s14 x3_re_a13 0 -64349.03576802614
Gr3_im_14_13 0 s14 x3_im_a13 0 -26610.68016905606
Gr4_14_13 0 s14 x4_a13 0 -0.16242044799634742
Gr5_14_13 0 s14 x5_a13 0 0.15850017125001553
Gd14_14 0 s14 p14 0 0.0014857890304441769
Fd14_14 0 s14 V14 0.07428945152220885
Gr1_14_14 0 s14 x1_a14 0 0.45711669845044156
Gr2_14_14 0 s14 x2_a14 0 -0.02307241697161556
Gr3_re_14_14 0 s14 x3_re_a14 0 56089.358090761394
Gr3_im_14_14 0 s14 x3_im_a14 0 31075.750823353563
Gr4_14_14 0 s14 x4_a14 0 0.16312781730722345
Gr5_14_14 0 s14 x5_a14 0 -0.05672518844030551
Gd14_15 0 s14 p15 0 -4.2488131923872695e-05
Fd14_15 0 s14 V15 -0.002124406596193635
Gr1_14_15 0 s14 x1_a15 0 -0.3976306160017764
Gr2_14_15 0 s14 x2_a15 0 0.11183469315382932
Gr3_re_14_15 0 s14 x3_re_a15 0 -38562.991194644455
Gr3_im_14_15 0 s14 x3_im_a15 0 -24418.289763721008
Gr4_14_15 0 s14 x4_a15 0 -0.13791838503962098
Gr5_14_15 0 s14 x5_a15 0 0.006464577610017693
Cx1_a14 x1_a14 0 1.5871725736917026e-13
Gx1_a14 0 x1_a14 p14 0 0.016242008282413824
Fx1_a14 0 x1_a14 V14 0.8121004141206912
Rp1_a14 0 x1_a14 1.0 noisy=0
Cx2_a14 x2_a14 0 3.688153046977837e-13
Gx2_a14 0 x2_a14 p14 0 0.009311613466398012
Fx2_a14 0 x2_a14 V14 0.46558067331990066
Rp2_a14 0 x2_a14 1.0 noisy=0
Cx3_re_a14 x3_re_a14 0 2.3135888003926714e-12
Gx3_re_a14 0 x3_re_a14 p14 0 8.086347752541717e-09
Fx3_re_a14 0 x3_re_a14 V14 4.043173876270858e-07
Rp3_re_re_a14 0 x3_re_a14 1.0 noisy=0
Gp3_re_im_a14 0 x3_re_a14 x3_im_a14 0 2.9111243944429863
Cx3_im_a14 x3_im_a14 0 2.3135888003926714e-12
Gp3_im_re_a14 0 x3_im_a14 x3_re_a14 0 -2.9111243944429863
Rp3_im_im_a14 0 x3_im_a14 1.0 noisy=0
Cx4_a14 x4_a14 0 1.3081951314894418e-11
Gx4_a14 0 x4_a14 p14 0 0.00911734172679303
Fx4_a14 0 x4_a14 V14 0.45586708633965156
Rp4_a14 0 x4_a14 1.0 noisy=0
Cx5_a14 x5_a14 0 8.108684533816161e-13
Gx5_a14 0 x5_a14 p14 0 0.003400965703029712
Fx5_a14 0 x5_a14 V14 0.1700482851514856
Rp5_a14 0 x5_a14 1.0 noisy=0
V15 p15 s15 0.0
R15 s15 0 50.0 noisy=0
Gd15_1 0 s15 p1 0 1.881653809866981e-05
Fd15_1 0 s15 V1 0.0009408269049334906
Gr1_15_1 0 s15 x1_a1 0 0.002035735849131957
Gr2_15_1 0 s15 x2_a1 0 -0.001771971067731961
Gr3_re_15_1 0 s15 x3_re_a1 0 -3000.132231857507
Gr3_im_15_1 0 s15 x3_im_a1 0 3273.8379864186336
Gr4_15_1 0 s15 x4_a1 0 0.1465468194722237
Gr5_15_1 0 s15 x5_a1 0 -0.001641090797086756
Gd15_2 0 s15 p2 0 -6.175065126581954e-05
Fd15_2 0 s15 V2 -0.003087532563290977
Gr1_15_2 0 s15 x1_a2 0 0.0051865080819436535
Gr2_15_2 0 s15 x2_a2 0 -0.0038367319055299196
Gr3_re_15_2 0 s15 x3_re_a2 0 -310.30072691998333
Gr3_im_15_2 0 s15 x3_im_a2 0 910.198621144823
Gr4_15_2 0 s15 x4_a2 0 0.07200905464219755
Gr5_15_2 0 s15 x5_a2 0 0.001194047342932804
Gd15_3 0 s15 p3 0 2.771510452016176e-05
Fd15_3 0 s15 V3 0.0013857552260080881
Gr1_15_3 0 s15 x1_a3 0 -0.0030067042452371724
Gr2_15_3 0 s15 x2_a3 0 0.0010325936309719497
Gr3_re_15_3 0 s15 x3_re_a3 0 869.049655397849
Gr3_im_15_3 0 s15 x3_im_a3 0 83.5977707674196
Gr4_15_3 0 s15 x4_a3 0 -0.0715759705216961
Gr5_15_3 0 s15 x5_a3 0 -0.0018583000797166237
Gd15_4 0 s15 p4 0 -0.00015443723499908004
Fd15_4 0 s15 V4 -0.007721861749954002
Gr1_15_4 0 s15 x1_a4 0 0.009516888579081815
Gr2_15_4 0 s15 x2_a4 0 5.032009726024424e-05
Gr3_re_15_4 0 s15 x3_re_a4 0 -1936.2857827470455
Gr3_im_15_4 0 s15 x3_im_a4 0 1947.149930524415
Gr4_15_4 0 s15 x4_a4 0 0.12461262805332146
Gr5_15_4 0 s15 x5_a4 0 0.001368844936528364
Gd15_5 0 s15 p5 0 2.7786467407680907e-05
Fd15_5 0 s15 V5 0.0013893233703840453
Gr1_15_5 0 s15 x1_a5 0 -0.0075613963234866894
Gr2_15_5 0 s15 x2_a5 0 0.007331821707112376
Gr3_re_15_5 0 s15 x3_re_a5 0 1819.468643735999
Gr3_im_15_5 0 s15 x3_im_a5 0 -1315.2073990028134
Gr4_15_5 0 s15 x4_a5 0 -0.1011733702914392
Gr5_15_5 0 s15 x5_a5 0 -0.0018350001326013887
Gd15_6 0 s15 p6 0 0.0057296929881104856
Fd15_6 0 s15 V6 0.2864846494055243
Gr1_15_6 0 s15 x1_a6 0 0.4891244592016126
Gr2_15_6 0 s15 x2_a6 0 -0.3035533642486255
Gr3_re_15_6 0 s15 x3_re_a6 0 -38006.826938311584
Gr3_im_15_6 0 s15 x3_im_a6 0 -19684.13102287503
Gr4_15_6 0 s15 x4_a6 0 -0.09854903895310285
Gr5_15_6 0 s15 x5_a6 0 0.10190401191460322
Gd15_7 0 s15 p7 0 -0.001997392225722987
Fd15_7 0 s15 V7 -0.09986961128614935
Gr1_15_7 0 s15 x1_a7 0 -0.7202660119433544
Gr2_15_7 0 s15 x2_a7 0 0.39449722489854466
Gr3_re_15_7 0 s15 x3_re_a7 0 39651.98545074305
Gr3_im_15_7 0 s15 x3_im_a7 0 17622.215724709196
Gr4_15_7 0 s15 x4_a7 0 0.0980258763932122
Gr5_15_7 0 s15 x5_a7 0 -0.1230186674335477
Gd15_8 0 s15 p8 0 0.00016638081496565455
Fd15_8 0 s15 V8 0.008319040748282727
Gr1_15_8 0 s15 x1_a8 0 -0.4571776584097944
Gr2_15_8 0 s15 x2_a8 0 0.26944943201816357
Gr3_re_15_8 0 s15 x3_re_a8 0 51227.52719416271
Gr3_im_15_8 0 s15 x3_im_a8 0 30322.38438477348
Gr4_15_8 0 s15 x4_a8 0 0.1518848269096919
Gr5_15_8 0 s15 x5_a8 0 -0.09698250314997188
Gd15_9 0 s15 p9 0 0.0001695297535265875
Fd15_9 0 s15 V9 0.008476487676329376
Gr1_15_9 0 s15 x1_a9 0 0.42913880606878246
Gr2_15_9 0 s15 x2_a9 0 -0.2567494153700068
Gr3_re_15_9 0 s15 x3_re_a9 0 -53163.746659412456
Gr3_im_15_9 0 s15 x3_im_a9 0 -28879.70913923993
Gr4_15_9 0 s15 x4_a9 0 -0.15212444763897143
Gr5_15_9 0 s15 x5_a9 0 0.09629585174240803
Gd15_10 0 s15 p10 0 -0.00015389715275771209
Fd15_10 0 s15 V10 -0.007694857637885605
Gr1_15_10 0 s15 x1_a10 0 0.008584654102740884
Gr2_15_10 0 s15 x2_a10 0 0.0002798464012414369
Gr3_re_15_10 0 s15 x3_re_a10 0 -3428.1443430932586
Gr3_im_15_10 0 s15 x3_im_a10 0 2136.225359404898
Gr4_15_10 0 s15 x4_a10 0 0.19524630876092813
Gr5_15_10 0 s15 x5_a10 0 -0.000864998459815035
Gd15_11 0 s15 p11 0 -2.020477768686285e-05
Fd15_11 0 s15 V11 -0.0010102388843431424
Gr1_15_11 0 s15 x1_a11 0 0.007383931701551599
Gr2_15_11 0 s15 x2_a11 0 -0.007695285914048462
Gr3_re_15_11 0 s15 x3_re_a11 0 2553.9602904565236
Gr3_im_15_11 0 s15 x3_im_a11 0 -3519.1846105693207
Gr4_15_11 0 s15 x4_a11 0 -0.14623374477372805
Gr5_15_11 0 s15 x5_a11 0 0.0015583544009471
Gd15_12 0 s15 p12 0 -3.588994227646387e-05
Fd15_12 0 s15 V12 -0.0017944971138231934
Gr1_15_12 0 s15 x1_a12 0 0.0041449988437148415
Gr2_15_12 0 s15 x2_a12 0 0.0004426680695133803
Gr3_re_15_12 0 s15 x3_re_a12 0 140.5147694631454
Gr3_im_15_12 0 s15 x3_im_a12 0 -1532.3889775557645
Gr4_15_12 0 s15 x4_a12 0 -0.12995200975071425
Gr5_15_12 0 s15 x5_a12 0 0.0009694082875217689
Gd15_13 0 s15 p13 0 0.0012278838358149012
Fd15_13 0 s15 V13 0.06139419179074506
Gr1_15_13 0 s15 x1_a13 0 0.2593162560666151
Gr2_15_13 0 s15 x2_a13 0 -0.056485799346577485
Gr3_re_15_13 0 s15 x3_re_a13 0 35636.77371299491
Gr3_im_15_13 0 s15 x3_im_a13 0 21539.670670779138
Gr4_15_13 0 s15 x4_a13 0 0.11641901702459621
Gr5_15_13 0 s15 x5_a13 0 -0.011871053337372234
Gd15_14 0 s15 p14 0 -4.248362338554118e-05
Fd15_14 0 s15 V14 -0.002124181169277059
Gr1_15_14 0 s15 x1_a14 0 -0.3526667123700176
Gr2_15_14 0 s15 x2_a14 0 0.09476164198973196
Gr3_re_15_14 0 s15 x3_re_a14 0 -33205.18672950015
Gr3_im_15_14 0 s15 x3_im_a14 0 -21025.4885481237
Gr4_15_14 0 s15 x4_a14 0 -0.11656488542187471
Gr5_15_14 0 s15 x5_a14 0 0.005505354524995345
Gd15_15 0 s15 p15 0 0.002013222084986826
Fd15_15 0 s15 V15 0.10066110424934131
Gr1_15_15 0 s15 x1_a15 0 0.6904856467168317
Gr2_15_15 0 s15 x2_a15 0 -0.1986803439632147
Gr3_re_15_15 0 s15 x3_re_a15 0 29681.570687512234
Gr3_im_15_15 0 s15 x3_im_a15 0 22010.65791975153
Gr4_15_15 0 s15 x4_a15 0 0.09830822638639895
Gr5_15_15 0 s15 x5_a15 0 0.001865844978355768
Cx1_a15 x1_a15 0 1.5871725736917026e-13
Gx1_a15 0 x1_a15 p15 0 0.014405333128895692
Fx1_a15 0 x1_a15 V15 0.7202666564447846
Rp1_a15 0 x1_a15 1.0 noisy=0
Cx2_a15 x2_a15 0 3.688153046977837e-13
Gx2_a15 0 x2_a15 p15 0 0.00788995150462911
Fx2_a15 0 x2_a15 V15 0.3944975752314555
Rp2_a15 0 x2_a15 1.0 noisy=0
Cx3_re_a15 x3_re_a15 0 2.3135888003926714e-12
Gx3_re_a15 0 x3_re_a15 p15 0 6.962855075967812e-09
Fx3_re_a15 0 x3_re_a15 V15 3.481427537983906e-07
Rp3_re_re_a15 0 x3_re_a15 1.0 noisy=0
Gp3_re_im_a15 0 x3_re_a15 x3_im_a15 0 2.9111243944429863
Cx3_im_a15 x3_im_a15 0 2.3135888003926714e-12
Gp3_im_re_a15 0 x3_im_a15 x3_re_a15 0 -2.9111243944429863
Rp3_im_im_a15 0 x3_im_a15 1.0 noisy=0
Cx4_a15 x4_a15 0 1.3081951314894418e-11
Gx4_a15 0 x4_a15 p15 0 0.007705730445562134
Fx4_a15 0 x4_a15 V15 0.3852865222781067
Rp4_a15 0 x4_a15 1.0 noisy=0
Cx5_a15 x5_a15 0 8.108684533816161e-13
Gx5_a15 0 x5_a15 p15 0 0.002896842357461599
Fx5_a15 0 x5_a15 V15 0.14484211787307996
Rp5_a15 0 x5_a15 1.0 noisy=0
Rnz_e1 nz_e1 0 0.25
Rnz_e2 nz_e2 0 0.25
Rnz_e3 nz_e3 0 0.25
Rnz_e4 nz_e4 0 0.25
Rnz_e5 nz_e5 0 0.25
Rnz_e6 nz_e6 0 0.25
Rnz_e7 nz_e7 0 0.25
Rnz_e8 nz_e8 0 0.25
Rnz_e9 nz_e9 0 0.25
Rnz_e10 nz_e10 0 0.25
Rnz_e11 nz_e11 0 0.25
Rnz_e12 nz_e12 0 0.25
Rnz_e13 nz_e13 0 0.25
Rnz_e14 nz_e14 0 0.25
Rnz_e15 nz_e15 0 0.25
Cnz_x1 nz_x1 0 1.5871725736917026e-13
Gnz_a1_1 0 nz_x1 nz_x1 0 -1.0
Gnz_k1_1 0 nz_x1 nz_e1 0 0.4712538129404236
Gnz_k1_2 0 nz_x1 nz_e2 0 -0.01894751740903937
Gnz_k1_3 0 nz_x1 nz_e3 0 0.020246506187546757
Gnz_k1_4 0 nz_x1 nz_e4 0 -0.02313462833691049
Gnz_k1_5 0 nz_x1 nz_e5 0 -0.02162050779263221
Gnz_k1_6 0 nz_x1 nz_e6 0 0.005537693225335381
Gnz_k1_7 0 nz_x1 nz_e7 0 -0.002225854872099391
Gnz_k1_8 0 nz_x1 nz_e8 0 -0.0026259524233217288
Gnz_k1_9 0 nz_x1 nz_e9 0 0.0014565951028314736
Gnz_k1_10 0 nz_x1 nz_e10 0 -0.036752701849815765
Gnz_k1_11 0 nz_x1 nz_e11 0 -0.07727039960024612
Gnz_k1_12 0 nz_x1 nz_e12 0 -0.03471424606061149
Gnz_k1_13 0 nz_x1 nz_e13 0 0.0012919583152537157
Gnz_k1_14 0 nz_x1 nz_e14 0 0.002779040484223554
Gnz_k1_15 0 nz_x1 nz_e15 0 -0.009908716815235764
Cnz_x2 nz_x2 0 1.5871725736917026e-13
Gnz_a2_2 0 nz_x2 nz_x2 0 -0.4303434682550038
Gnz_k2_1 0 nz_x2 nz_e1 0 0.3526707157366203
Gnz_k2_2 0 nz_x2 nz_e2 0 -0.06645761148575399
Gnz_k2_3 0 nz_x2 nz_e3 0 0.09846011228323989
Gnz_k2_4 0 nz_x2 nz_e4 0 -0.16454764916618145
Gnz_k2_5 0 nz_x2 nz_e5 0 0.12595010974771362
Gnz_k2_6 0 nz_x2 nz_e6 0 0.008252929889736619
Gnz_k2_7 0 nz_x2 nz_e7 0 -0.00516531743958134
Gnz_k2_8 0 nz_x2 nz_e8 0 -0.01017345421195389
Gnz_k2_9 0 nz_x2 nz_e9 0 0.007584327125030352
Gnz_k2_10 0 nz_x2 nz_e10 0 0.2851160988704888
Gnz_k2_11 0 nz_x2 nz_e11 0 -0.5524759819001716
Gnz_k2_12 0 nz_x2 nz_e12 0 0.24181273893921826
Gnz_k2_13 0 nz_x2 nz_e13 0 0.00020611405626230127
Gnz_k2_14 0 nz_x2 nz_e14 0 0.005797990277765928
Gnz_k2_15 0 nz_x2 nz_e15 0 -0.008840086698620244
Cnz_x3 nz_x3 0 1.5871725736917026e-13
Gnz_a3_3 0 nz_x3 nz_x3 0 -0.0686021895257412
Gnz_a3_4 0 nz_x3 nz_x4 0 0.19970950744058633
Gnz_k3_1 0 nz_x3 nz_e1 0 0.022206592529721136
Gnz_k3_2 0 nz_x3 nz_e2 0 0.001885032049005069
Gnz_k3_3 0 nz_x3 nz_e3 0 -0.0003401745172885145
Gnz_k3_4 0 nz_x3 nz_e4 0 -0.0008968715495285876
Gnz_k3_5 0 nz_x3 nz_e5 0 -0.0008271313249809278
Gnz_k3_6 0 nz_x3 nz_e6 0 0.000355802089688028
Gnz_k3_7 0 nz_x3 nz_e7 0 -2.2662888971503287e-05
Gnz_k3_8 0 nz_x3 nz_e8 0 0.00014634254644411797
Gnz_k3_9 0 nz_x3 nz_e9 0 -8.20650795937651e-05
Gnz_k3_10 0 nz_x3 nz_e10 0 -0.005584246757676456
Gnz_k3_11 0 nz_x3 nz_e11 0 0.0026104557294445905
Gnz_k3_12 0 nz_x3 nz_e12 0 -0.005348496819327066
Gnz_k3_13 0 nz_x3 nz_e13 0 5.159150160563798e-05
Gnz_k3_14 0 nz_x3 nz_e14 0 0.0004884438590109439
Gnz_k3_15 0 nz_x3 nz_e15 0 -0.0005508130033090913
Cnz_x4 nz_x4 0 1.5871725736917026e-13
Gnz_a4_3 0 nz_x4 nz_x3 0 -0.19970950744058633
Gnz_a4_4 0 nz_x4 nz_x4 0 -0.0686021895257412
Gnz_k4_1 0 nz_x4 nz_e1 0 0.007586202100998366
Gnz_k4_2 0 nz_x4 nz_e2 0 0.003054934203155415
Gnz_k4_3 0 nz_x4 nz_e3 0 -0.006718305921184785
Gnz_k4_4 0 nz_x4 nz_e4 0 0.008557479289001276
Gnz_k4_5 0 nz_x4 nz_e5 0 -0.007290363697686244
Gnz_k4_6 0 nz_x4 nz_e6 0 -0.00029857384977179167
Gnz_k4_7 0 nz_x4 nz_e7 0 0.00026188591951682103
Gnz_k4_8 0 nz_x4 nz_e8 0 0.00032622473519975813
Gnz_k4_9 0 nz_x4 nz_e9 0 -0.0003034306360445286
Gnz_k4_10 0 nz_x4 nz_e10 0 -0.01807195434785491
Gnz_k4_11 0 nz_x4 nz_e11 0 0.028986302992412286
Gnz_k4_12 0 nz_x4 nz_e12 0 -0.013077945206212515
Gnz_k4_13 0 nz_x4 nz_e13 0 -3.46553333277153e-05
Gnz_k4_14 0 nz_x4 nz_e14 0 -0.0001894485454717284
Gnz_k4_15 0 nz_x4 nz_e15 0 0.00020044420989539813
Cnz_x5 nz_x5 0 1.5871725736917026e-13
Gnz_a5_5 0 nz_x5 nz_x5 0 -0.012132536924247928
Gnz_k5_1 0 nz_x5 nz_e1 0 -0.07454101210246025
Gnz_k5_2 0 nz_x5 nz_e2 0 -0.023432988739580593
Gnz_k5_3 0 nz_x5 nz_e3 0 0.0216589751874878
Gnz_k5_4 0 nz_x5 nz_e4 0 -0.037364195004939385
Gnz_k5_5 0 nz_x5 nz_e5 0 0.03707219509149503
Gnz_k5_6 0 nz_x5 nz_e6 0 -0.0005730838794818325
Gnz_k5_7 0 nz_x5 nz_e7 0 -0.000700578705678716
Gnz_k5_8 0 nz_x5 nz_e8 0 -0.0038797230461997804
Gnz_k5_9 0 nz_x5 nz_e9 0 0.00133300150291799
Gnz_k5_10 0 nz_x5 nz_e10 0 0.08694588244153825
Gnz_k5_11 0 nz_x5 nz_e11 0 -0.15103775948853526
Gnz_k5_12 0 nz_x5 nz_e12 0 0.08499434923211588
Gnz_k5_13 0 nz_x5 nz_e13 0 3.30339393217219e-05
Gnz_k5_14 0 nz_x5 nz_e14 0 -0.0016181169492550614
Gnz_k5_15 0 nz_x5 nz_e15 0 0.0011794972020457881
Cnz_x6 nz_x6 0 1.5871725736917026e-13
Gnz_a6_6 0 nz_x6 nz_x6 0 -0.19573736862898244
Gnz_k6_1 0 nz_x6 nz_e1 0 0.005990453115187529
Gnz_k6_2 0 nz_x6 nz_e2 0 -0.016632769428196543
Gnz_k6_3 0 nz_x6 nz_e3 0 0.025831376913190162
Gnz_k6_4 0 nz_x6 nz_e4 0 -0.04076637010489885
Gnz_k6_5 0 nz_x6 nz_e5 0 0.034632818812793224
Gnz_k6_6 0 nz_x6 nz_e6 0 0.0012735188022898714
Gnz_k6_7 0 nz_x6 nz_e7 0 -0.0011364649026696858
Gnz_k6_8 0 nz_x6 nz_e8 0 -0.0023633605481754487
Gnz_k6_9 0 nz_x6 nz_e9 0 0.0016880521968390431
Gnz_k6_10 0 nz_x6 nz_e10 0 0.0798281749427055
Gnz_k6_11 0 nz_x6 nz_e11 0 -0.14040442388331856
Gnz_k6_12 0 nz_x6 nz_e12 0 0.06650495241828538
Gnz_k6_13 0 nz_x6 nz_e13 0 6.092756833212988e-05
Gnz_k6_14 0 nz_x6 nz_e14 0 0.0005746565303772787
Gnz_k6_15 0 nz_x6 nz_e15 0 -0.0009124145466449244
Cnz_x7 nz_x7 0 1.5871725736917026e-13
Gnz_a7_7 0 nz_x7 nz_x7 0 -1.0000000000000002
Gnz_k7_1 0 nz_x7 nz_e1 0 0.009432999633756238
Gnz_k7_2 0 nz_x7 nz_e2 0 0.5398693613477671
Gnz_k7_3 0 nz_x7 nz_e3 0 -0.3377651567196083
Gnz_k7_4 0 nz_x7 nz_e4 0 0.0896295144260866
Gnz_k7_5 0 nz_x7 nz_e5 0 0.17961848376843412
Gnz_k7_6 0 nz_x7 nz_e6 0 -0.0008168237444019671
Gnz_k7_7 0 nz_x7 nz_e7 0 0.001908130863067702
Gnz_k7_8 0 nz_x7 nz_e8 0 -0.0002601116326220703
Gnz_k7_9 0 nz_x7 nz_e9 0 0.0009300532314574241
Gnz_k7_10 0 nz_x7 nz_e10 0 -0.09287318673379936
Gnz_k7_11 0 nz_x7 nz_e11 0 0.00908711176449006
Gnz_k7_12 0 nz_x7 nz_e12 0 0.21830364648240475
Gnz_k7_13 0 nz_x7 nz_e13 0 -0.0022709966280616825
Gnz_k7_14 0 nz_x7 nz_e14 0 0.004142909837393973
Gnz_k7_15 0 nz_x7 nz_e15 0 -0.0010851302841265187
Cnz_x8 nz_x8 0 1.5871725736917026e-13
Gnz_a8_8 0 nz_x8 nz_x8 0 -0.4303434682550038
Gnz_k8_1 0 nz_x8 nz_e1 0 0.008062353977425508
Gnz_k8_2 0 nz_x8 nz_e2 0 0.25673677961828556
Gnz_k8_3 0 nz_x8 nz_e3 0 -0.5408663694001647
Gnz_k8_4 0 nz_x8 nz_e4 0 0.13121798217003
Gnz_k8_5 0 nz_x8 nz_e5 0 0.504275163162345
Gnz_k8_6 0 nz_x8 nz_e6 0 0.0021876844545463433
Gnz_k8_7 0 nz_x8 nz_e7 0 -0.00048486316406086844
Gnz_k8_8 0 nz_x8 nz_e8 0 -0.0007587016368325275
Gnz_k8_9 0 nz_x8 nz_e9 0 0.0019521063375478826
Gnz_k8_10 0 nz_x8 nz_e10 0 -0.03160456402622893
Gnz_k8_11 0 nz_x8 nz_e11 0 -0.017345515091150163
Gnz_k8_12 0 nz_x8 nz_e12 0 0.056432567262297506
Gnz_k8_13 0 nz_x8 nz_e13 0 -0.0012134762778180147
Gnz_k8_14 0 nz_x8 nz_e14 0 0.0035152886920033887
Gnz_k8_15 0 nz_x8 nz_e15 0 -0.003765792947747666
Cnz_x9 nz_x9 0 1.5871725736917026e-13
Gnz_a9_9 0 nz_x9 nz_x9 0 -0.0686021895257412
Gnz_a9_10 0 nz_x9 nz_x10 0 0.19970950744058633
Gnz_k9_1 0 nz_x9 nz_e1 0 0.002624856638899229
Gnz_k9_2 0 nz_x9 nz_e2 0 0.013198631507110816
Gnz_k9_3 0 nz_x9 nz_e3 0 -0.014818395718098735
Gnz_k9_4 0 nz_x9 nz_e4 0 0.0009690685280784488
Gnz_k9_5 0 nz_x9 nz_e5 0 0.007374302504730027
Gnz_k9_6 0 nz_x9 nz_e6 0 0.00011689438596319167
Gnz_k9_7 0 nz_x9 nz_e7 0 6.915511562199642e-05
Gnz_k9_8 0 nz_x9 nz_e8 0 0.000292825800344856
Gnz_k9_9 0 nz_x9 nz_e9 0 -6.144233330270325e-05
Gnz_k9_10 0 nz_x9 nz_e10 0 -0.0013321755571578746
Gnz_k9_11 0 nz_x9 nz_e11 0 -0.00017002558943430716
Gnz_k9_12 0 nz_x9 nz_e12 0 0.0066881950690658365
Gnz_k9_13 0 nz_x9 nz_e13 0 2.782643973813612e-05
Gnz_k9_14 0 nz_x9 nz_e14 0 9.703446584018128e-05
Gnz_k9_15 0 nz_x9 nz_e15 0 -0.00014158450493511089
Cnz_x10 nz_x10 0 1.5871725736917026e-13
Gnz_a10_9 0 nz_x10 nz_x9 0 -0.19970950744058633
Gnz_a10_10 0 nz_x10 nz_x10 0 -0.0686021895257412
Gnz_k10_1 0 nz_x10 nz_e1 0 0.0021487162405016322
Gnz_k10_2 0 nz_x10 nz_e2 0 0.030897794941551416
Gnz_k10_3 0 nz_x10 nz_e3 0 0.03226070009821456
Gnz_k10_4 0 nz_x10 nz_e4 0 -0.015457901502554721
Gnz_k10_5 0 nz_x10 nz_e5 0 -0.02971011168910847
Gnz_k10_6 0 nz_x10 nz_e6 0 -0.0003808247127906371
Gnz_k10_7 0 nz_x10 nz_e7 0 0.00011931384951921164
Gnz_k10_8 0 nz_x10 nz_e8 0 -3.4428074326644384e-05
Gnz_k10_9 0 nz_x10 nz_e9 0 -0.0002585650799093277
Gnz_k10_10 0 nz_x10 nz_e10 0 -0.0025646671972434174
Gnz_k10_11 0 nz_x10 nz_e11 0 -0.0029814487835964332
Gnz_k10_12 0 nz_x10 nz_e12 0 0.007121314690411846
Gnz_k10_13 0 nz_x10 nz_e13 0 0.00014996192666759292
Gnz_k10_14 0 nz_x10 nz_e14 0 -0.00044182825401453376
Gnz_k10_15 0 nz_x10 nz_e15 0 0.000436815457677865
Cnz_x11 nz_x11 0 1.5871725736917026e-13
Gnz_a11_11 0 nz_x11 nz_x11 0 -0.012132536924247928
Gnz_k11_1 0 nz_x11 nz_e1 0 -0.0064746337521497275
Gnz_k11_2 0 nz_x11 nz_e2 0 -0.050165132010656824
Gnz_k11_3 0 nz_x11 nz_e3 0 -0.04732131587338979
Gnz_k11_4 0 nz_x11 nz_e4 0 0.017903462990498335
Gnz_k11_5 0 nz_x11 nz_e5 0 0.062028770689851506
Gnz_k11_6 0 nz_x11 nz_e6 0 -0.00031157884876874243
Gnz_k11_7 0 nz_x11 nz_e7 0 -0.00011848256989634794
Gnz_k11_8 0 nz_x11 nz_e8 0 -0.001777073218848036
Gnz_k11_9 0 nz_x11 nz_e9 0 -0.0001261094508034704
Gnz_k11_10 0 nz_x11 nz_e10 0 0.005799843838007452
Gnz_k11_11 0 nz_x11 nz_e11 0 -0.004201056141507327
Gnz_k11_12 0 nz_x11 nz_e12 0 -0.032562363593163855
Gnz_k11_13 0 nz_x11 nz_e13 0 0.00013565086503514854
Gnz_k11_14 0 nz_x11 nz_e14 0 -6.192369023438643e-05
Gnz_k11_15 0 nz_x11 nz_e15 0 0.00027236086108781
Cnz_x12 nz_x12 0 1.5871725736917026e-13
Gnz_a12_12 0 nz_x12 nz_x12 0 -0.19573736862898244
Gnz_k12_1 0 nz_x12 nz_e1 0 -0.004479584643387745
Gnz_k12_2 0 nz_x12 nz_e2 0 -0.07951801731619565
Gnz_k12_3 0 nz_x12 nz_e3 0 -0.26119066699139665
Gnz_k12_4 0 nz_x12 nz_e4 0 0.08639662115001596
Gnz_k12_5 0 nz_x12 nz_e5 0 0.2575373307276
Gnz_k12_6 0 nz_x12 nz_e6 0 0.001364496164117747
Gnz_k12_7 0 nz_x12 nz_e7 0 -0.0006923610853078232
Gnz_k12_8 0 nz_x12 nz_e8 0 -0.0010142735613888258
Gnz_k12_9 0 nz_x12 nz_e9 0 0.0012818643384121633
Gnz_k12_10 0 nz_x12 nz_e10 0 0.0021265289147235694
Gnz_k12_11 0 nz_x12 nz_e11 0 -0.0016018983285653722
Gnz_k12_12 0 nz_x12 nz_e12 0 -0.028601358575133417
Gnz_k12_13 0 nz_x12 nz_e13 0 -0.0006267611155448248
Gnz_k12_14 0 nz_x12 nz_e14 0 0.001835726243279421
Gnz_k12_15 0 nz_x12 nz_e15 0 -0.0017597078817344117
Cnz_x13 nz_x13 0 1.5871725736917026e-13
Gnz_a13_13 0 nz_x13 nz_x13 0 -1.0
Gnz_k13_1 0 nz_x13 nz_e1 0 -0.021162619823397972
Gnz_k13_2 0 nz_x13 nz_e2 0 0.14337915249068428
Gnz_k13_3 0 nz_x13 nz_e3 0 0.5749177692405252
Gnz_k13_4 0 nz_x13 nz_e4 0 -0.28601471496862496
Gnz_k13_5 0 nz_x13 nz_e5 0 -0.7147685112251286
Gnz_k13_6 0 nz_x13 nz_e6 0 -0.000352358281198306
Gnz_k13_7 0 nz_x13 nz_e7 0 -0.00012712921661573793
Gnz_k13_8 0 nz_x13 nz_e8 0 0.001733455615738835
Gnz_k13_9 0 nz_x13 nz_e9 0 -0.0020182154367046276
Gnz_k13_10 0 nz_x13 nz_e10 0 0.05715363827691167
Gnz_k13_11 0 nz_x13 nz_e11 0 -0.025737160763788017
Gnz_k13_12 0 nz_x13 nz_e12 0 -3.9575929474128435e-05
Gnz_k13_13 0 nz_x13 nz_e13 0 0.0018813300800762946
Gnz_k13_14 0 nz_x13 nz_e14 0 -0.002535360538040989
Gnz_k13_15 0 nz_x13 nz_e15 0 0.000620749945570742
Cnz_x14 nz_x14 0 1.5871725736917026e-13
Gnz_a14_14 0 nz_x14 nz_x14 0 -0.4303434682550038
Gnz_k14_1 0 nz_x14 nz_e1 0 0.056237613882304055
Gnz_k14_2 0 nz_x14 nz_e2 0 -0.013181425065167519
Gnz_k14_3 0 nz_x14 nz_e3 0 0.04506071273333021
Gnz_k14_4 0 nz_x14 nz_e4 0 -0.5521404980355101
Gnz_k14_5 0 nz_x14 nz_e5 0 -0.45673617489450263
Gnz_k14_6 0 nz_x14 nz_e6 0 -6.28815497660626e-05
Gnz_k14_7 0 nz_x14 nz_e7 0 -0.0003263559357567798
Gnz_k14_8 0 nz_x14 nz_e8 0 0.002957644338650118
Gnz_k14_9 0 nz_x14 nz_e9 0 -0.0016267904051671125
Gnz_k14_10 0 nz_x14 nz_e10 0 0.0805356832734437
Gnz_k14_11 0 nz_x14 nz_e11 0 -0.014113359281376076
Gnz_k14_12 0 nz_x14 nz_e12 0 0.034145096531673746
Gnz_k14_13 0 nz_x14 nz_e13 0 0.0012546659429141095
Gnz_k14_14 0 nz_x14 nz_e14 0 -0.0020398583731703022
Gnz_k14_15 0 nz_x14 nz_e15 0 0.000924316223784308
Cnz_x15 nz_x15 0 1.5871725736917026e-13
Gnz_a15_15 0 nz_x15 nz_x15 0 -0.0686021895257412
Gnz_a15_16 0 nz_x15 nz_x16 0 0.19970950744058633
Gnz_k15_1 0 nz_x15 nz_e1 0 0.007363921897376001
Gnz_k15_2 0 nz_x15 nz_e2 0 0.00467847126607158
Gnz_k15_3 0 nz_x15 nz_e3 0 -0.013151011118671872
Gnz_k15_4 0 nz_x15 nz_e4 0 -0.03145602209630151
Gnz_k15_5 0 nz_x15 nz_e5 0 -0.011827273041363441
Gnz_k15_6 0 nz_x15 nz_e6 0 0.00011875094367283917
Gnz_k15_7 0 nz_x15 nz_e7 0 -2.0761917623893784e-05
Gnz_k15_8 0 nz_x15 nz_e8 0 0.0004039999524684159
Gnz_k15_9 0 nz_x15 nz_e9 0 -6.856178997155155e-05
Gnz_k15_10 0 nz_x15 nz_e10 0 0.004411116620048415
Gnz_k15_11 0 nz_x15 nz_e11 0 0.00013541250689277793
Gnz_k15_12 0 nz_x15 nz_e12 0 0.0050838592154515685
Gnz_k15_13 0 nz_x15 nz_e13 0 5.978208420739388e-05
Gnz_k15_14 0 nz_x15 nz_e14 0 -9.05260612141815e-06
Gnz_k15_15 0 nz_x15 nz_e15 0 -8.357678170684239e-05
Cnz_x16 nz_x16 0 1.5871725736917026e-13
Gnz_a16_15 0 nz_x16 nz_x15 0 -0.19970950744058633
Gnz_a16_16 0 nz_x16 nz_x16 0 -0.0686021895257412
Gnz_k16_1 0 nz_x16 nz_e1 0 -0.0030334014680309
Gnz_k16_2 0 nz_x16 nz_e2 0 0.024938593406539766
Gnz_k16_3 0 nz_x16 nz_e3 0 0.036330967672088085
Gnz_k16_4 0 nz_x16 nz_e4 0 0.015759073726977532
Gnz_k16_5 0 nz_x16 nz_e5 0 -0.010547372296525585
Gnz_k16_6 0 nz_x16 nz_e6 0 -0.00017389856065252947
Gnz_k16_7 0 nz_x16 nz_e7 0 0.0002403943962300208
Gnz_k16_8 0 nz_x16 nz_e8 0 1.3789296112642152e-05
Gnz_k16_9 0 nz_x16 nz_e9 0 -0.00031573134664044186
Gnz_k16_10 0 nz_x16 nz_e10 0 -0.0021774212691486974
Gnz_k16_11 0 nz_x16 nz_e11 0 -0.0008583553923289472
Gnz_k16_12 0 nz_x16 nz_e12 0 0.006720049310077224
Gnz_k16_13 0 nz_x16 nz_e13 0 0.00012195991084406515
Gnz_k16_14 0 nz_x16 nz_e14 0 2.701267407870738e-05
Gnz_k16_15 0 nz_x16 nz_e15 0 6.907873372864873e-06
Cnz_x17 nz_x17 0 1.5871725736917026e-13
Gnz_a17_17 0 nz_x17 nz_x17 0 -0.012132536924247928
Gnz_k17_1 0 nz_x17 nz_e1 0 -0.00034027375111871674
Gnz_k17_2 0 nz_x17 nz_e2 0 -0.06307263282342761
Gnz_k17_3 0 nz_x17 nz_e3 0 -0.06188349606562631
Gnz_k17_4 0 nz_x17 nz_e4 0 -0.0226116961901262
Gnz_k17_5 0 nz_x17 nz_e5 0 0.040788468931456344
Gnz_k17_6 0 nz_x17 nz_e6 0 -0.0005344209635031418
Gnz_k17_7 0 nz_x17 nz_e7 0 -0.00030174386351268685
Gnz_k17_8 0 nz_x17 nz_e8 0 -0.0018401605662615418
Gnz_k17_9 0 nz_x17 nz_e9 0 4.1956802995068384e-05
Gnz_k17_10 0 nz_x17 nz_e10 0 0.008331072737243655
Gnz_k17_11 0 nz_x17 nz_e11 0 -0.004751766200087395
Gnz_k17_12 0 nz_x17 nz_e12 0 -0.03592871981149096
Gnz_k17_13 0 nz_x17 nz_e13 0 0.0001194199055495902
Gnz_k17_14 0 nz_x17 nz_e14 0 -0.0005490562028331324
Gnz_k17_15 0 nz_x17 nz_e15 0 0.0007130220206647272
Cnz_x18 nz_x18 0 1.5871725736917026e-13
Gnz_a18_18 0 nz_x18 nz_x18 0 -0.19573736862898244
Gnz_k18_1 0 nz_x18 nz_e1 0 0.02331031368534874
Gnz_k18_2 0 nz_x18 nz_e2 0 -0.07694060476736293
Gnz_k18_3 0 nz_x18 nz_e3 0 -0.1158075145530637
Gnz_k18_4 0 nz_x18 nz_e4 0 -0.14369172460171842
Gnz_k18_5 0 nz_x18 nz_e5 0 -0.020790806271933835
Gnz_k18_6 0 nz_x18 nz_e6 0 0.0002575354565595966
Gnz_k18_7 0 nz_x18 nz_e7 0 -0.0005687475740754167
Gnz_k18_8 0 nz_x18 nz_e8 0 0.00018151721447767929
Gnz_k18_9 0 nz_x18 nz_e9 0 0.00030660860276634746
Gnz_k18_10 0 nz_x18 nz_e10 0 0.021935317465074832
Gnz_k18_11 0 nz_x18 nz_e11 0 -0.001610450339114152
Gnz_k18_12 0 nz_x18 nz_e12 0 -0.012704661843437465
Gnz_k18_13 0 nz_x18 nz_e13 0 8.593259380995293e-06
Gnz_k18_14 0 nz_x18 nz_e14 0 -0.0004133713964370168
Gnz_k18_15 0 nz_x18 nz_e15 0 0.00025233000172091176
Cnz_x19 nz_x19 0 1.5871725736917026e-13
Gnz_a19_19 0 nz_x19 nz_x19 0 -1.0
Gnz_k19_1 0 nz_x19 nz_e1 0 -0.027682508767494538
Gnz_k19_2 0 nz_x19 nz_e2 0 -0.18773572249847442
Gnz_k19_3 0 nz_x19 nz_e3 0 -0.49557050150809867
Gnz_k19_4 0 nz_x19 nz_e4 0 0.4909228916414228
Gnz_k19_5 0 nz_x19 nz_e5 0 -0.342584634054002
Gnz_k19_6 0 nz_x19 nz_e6 0 -0.00846766939862597
Gnz_k19_7 0 nz_x19 nz_e7 0 0.00665651288397219
Gnz_k19_8 0 nz_x19 nz_e8 0 0.004356895337983879
Gnz_k19_9 0 nz_x19 nz_e9 0 -0.0054792645308574615
Gnz_k19_10 0 nz_x19 nz_e10 0 -0.27901797077602924
Gnz_k19_11 0 nz_x19 nz_e11 0 0.11531065101248533
Gnz_k19_12 0 nz_x19 nz_e12 0 0.4790987092427915
Gnz_k19_13 0 nz_x19 nz_e13 0 -0.0015892710970901662
Gnz_k19_14 0 nz_x19 nz_e14 0 -0.003478316375561684
Gnz_k19_15 0 nz_x19 nz_e15 0 0.008063823375351014
Cnz_x20 nz_x20 0 1.5871725736917026e-13
Gnz_a20_20 0 nz_x20 nz_x20 0 -0.4303434682550038
Gnz_k20_1 0 nz_x20 nz_e1 0 -0.0345384862518143
Gnz_k20_2 0 nz_x20 nz_e2 0 0.04299556197910471
Gnz_k20_3 0 nz_x20 nz_e3 0 -0.49091658977191965
Gnz_k20_4 0 nz_x20 nz_e4 0 -0.09271336199403844
Gnz_k20_5 0 nz_x20 nz_e5 0 -0.14097694046295584
Gnz_k20_6 0 nz_x20 nz_e6 0 -0.00016158263906343665
Gnz_k20_7 0 nz_x20 nz_e7 0 -0.0003276089597192206
Gnz_k20_8 0 nz_x20 nz_e8 0 -0.0028745758224889215
Gnz_k20_9 0 nz_x20 nz_e9 0 0.0013827477772215668
Gnz_k20_10 0 nz_x20 nz_e10 0 -0.024060268253147183
Gnz_k20_11 0 nz_x20 nz_e11 0 -0.015970699267529236
Gnz_k20_12 0 nz_x20 nz_e12 0 -0.0342964916575723
Gnz_k20_13 0 nz_x20 nz_e13 0 -0.0011907008630308168
Gnz_k20_14 0 nz_x20 nz_e14 0 0.0002329801963415019
Gnz_k20_15 0 nz_x20 nz_e15 0 0.0002088536024488508
Cnz_x21 nz_x21 0 1.5871725736917026e-13
Gnz_a21_21 0 nz_x21 nz_x21 0 -0.0686021895257412
Gnz_a21_22 0 nz_x21 nz_x22 0 0.19970950744058633
Gnz_k21_1 0 nz_x21 nz_e1 0 0.00608415469993551
Gnz_k21_2 0 nz_x21 nz_e2 0 0.008129546235667801
Gnz_k21_3 0 nz_x21 nz_e3 0 -0.026729695581378464
Gnz_k21_4 0 nz_x21 nz_e4 0 -0.014573390701742928
Gnz_k21_5 0 nz_x21 nz_e5 0 -0.004172485140558864
Gnz_k21_6 0 nz_x21 nz_e6 0 0.0002548900994486301
Gnz_k21_7 0 nz_x21 nz_e7 0 -5.6588342621390936e-05
Gnz_k21_8 0 nz_x21 nz_e8 0 0.00012016636590962828
Gnz_k21_9 0 nz_x21 nz_e9 0 0.00011039005146890633
Gnz_k21_10 0 nz_x21 nz_e10 0 -0.002450502215627754
Gnz_k21_11 0 nz_x21 nz_e11 0 0.001855550727737092
Gnz_k21_12 0 nz_x21 nz_e12 0 0.006820738618060603
Gnz_k21_13 0 nz_x21 nz_e13 0 -5.633123946155402e-05
Gnz_k21_14 0 nz_x21 nz_e14 0 0.00019480352048616942
Gnz_k21_15 0 nz_x21 nz_e15 0 -0.00031779734468080054
Cnz_x22 nz_x22 0 1.5871725736917026e-13
Gnz_a22_21 0 nz_x22 nz_x21 0 -0.19970950744058633
Gnz_a22_22 0 nz_x22 nz_x22 0 -0.0686021895257412
Gnz_k22_1 0 nz_x22 nz_e1 0 0.0029054425966232845
Gnz_k22_2 0 nz_x22 nz_e2 0 -0.012192112005415937
Gnz_k22_3 0 nz_x22 nz_e3 0 0.012690102404458527
Gnz_k22_4 0 nz_x22 nz_e4 0 0.026729015317639233
Gnz_k22_5 0 nz_x22 nz_e5 0 -0.0021369604085090107
Gnz_k22_6 0 nz_x22 nz_e6 0 -0.00010426374642165078
Gnz_k22_7 0 nz_x22 nz_e7 0 0.0003429609199321423
Gnz_k22_8 0 nz_x22 nz_e8 0 0.000590594547194549
Gnz_k22_9 0 nz_x22 nz_e9 0 -0.00027116523448875315
Gnz_k22_10 0 nz_x22 nz_e10 0 -0.004194047247075019
Gnz_k22_11 0 nz_x22 nz_e11 0 0.012042553718900418
Gnz_k22_12 0 nz_x22 nz_e12 0 0.023592524756249875
Gnz_k22_13 0 nz_x22 nz_e13 0 -1.0602258592510111e-05
Gnz_k22_14 0 nz_x22 nz_e14 0 0.00021599992896992443
Gnz_k22_15 0 nz_x22 nz_e15 0 -1.8687988405921175e-05
Cnz_x23 nz_x23 0 1.5871725736917026e-13
Gnz_a23_23 0 nz_x23 nz_x23 0 -0.012132536924247928
Gnz_k23_1 0 nz_x23 nz_e1 0 -0.029522639067391578
Gnz_k23_2 0 nz_x23 nz_e2 0 0.027676960291861768
Gnz_k23_3 0 nz_x23 nz_e3 0 -0.024627853061014834
Gnz_k23_4 0 nz_x23 nz_e4 0 -0.08065959470315341
Gnz_k23_5 0 nz_x23 nz_e5 0 0.036369448473041105
Gnz_k23_6 0 nz_x23 nz_e6 0 -0.0015268821318692456
Gnz_k23_7 0 nz_x23 nz_e7 0 -0.0012030798463884605
Gnz_k23_8 0 nz_x23 nz_e8 0 -0.004504571602926098
Gnz_k23_9 0 nz_x23 nz_e9 0 0.00031108285718155893
Gnz_k23_10 0 nz_x23 nz_e10 0 0.04047216560952724
Gnz_k23_11 0 nz_x23 nz_e11 0 -0.05243892579898789
Gnz_k23_12 0 nz_x23 nz_e12 0 -0.152865319472135
Gnz_k23_13 0 nz_x23 nz_e13 0 0.0007172184686330454
Gnz_k23_14 0 nz_x23 nz_e14 0 -0.001901614170487826
Gnz_k23_15 0 nz_x23 nz_e15 0 0.0018495845755298677
Cnz_x24 nz_x24 0 1.5871725736917026e-13
Gnz_a24_24 0 nz_x24 nz_x24 0 -0.19573736862898244
Gnz_k24_1 0 nz_x24 nz_e1 0 -0.04263111686867886
Gnz_k24_2 0 nz_x24 nz_e2 0 0.1413116277627708
Gnz_k24_3 0 nz_x24 nz_e3 0 -0.3365972941233697
Gnz_k24_4 0 nz_x24 nz_e4 0 -0.2927468042574026
Gnz_k24_5 0 nz_x24 nz_e5 0 -0.019589798609636083
Gnz_k24_6 0 nz_x24 nz_e6 0 0.001215986889642784
Gnz_k24_7 0 nz_x24 nz_e7 0 -0.003215856628418685
Gnz_k24_8 0 nz_x24 nz_e8 0 -0.006693808402219525
Gnz_k24_9 0 nz_x24 nz_e9 0 0.003120903011259108
Gnz_k24_10 0 nz_x24 nz_e10 0 0.0619603247709972
Gnz_k24_11 0 nz_x24 nz_e11 0 -0.1085102579765951
Gnz_k24_12 0 nz_x24 nz_e12 0 -0.2486858777284035
Gnz_k24_13 0 nz_x24 nz_e13 0 -0.0003044508287168319
Gnz_k24_14 0 nz_x24 nz_e14 0 -0.0009339303835547244
Gnz_k24_15 0 nz_x24 nz_e15 0 -0.0005037839231807573
Cnz_x25 nz_x25 0 1.5871725736917026e-13
Gnz_a25_25 0 nz_x25 nz_x25 0 -1.0
Gnz_k25_1 0 nz_x25 nz_e1 0 0.05488048360114595
Gnz_k25_2 0 nz_x25 nz_e2 0 -0.005685560484243231
Gnz_k25_3 0 nz_x25 nz_e3 0 -0.47397018281648895
Gnz_k25_4 0 nz_x25 nz_e4 0 -0.3182170579374414
Gnz_k25_5 0 nz_x25 nz_e5 0 0.6917617178893504
Gnz_k25_6 0 nz_x25 nz_e6 0 0.004187304165359642
Gnz_k25_7 0 nz_x25 nz_e7 0 -0.004442652117279193
Gnz_k25_8 0 nz_x25 nz_e8 0 -0.006173767714823202
Gnz_k25_9 0 nz_x25 nz_e9 0 0.00505066720293222
Gnz_k25_10 0 nz_x25 nz_e10 0 0.11654614535487312
Gnz_k25_11 0 nz_x25 nz_e11 0 -0.07424704777391583
Gnz_k25_12 0 nz_x25 nz_e12 0 -0.2864857561787341
Gnz_k25_13 0 nz_x25 nz_e13 0 -0.0007390864385979688
Gnz_k25_14 0 nz_x25 nz_e14 0 0.0011599783594675168
Gnz_k25_15 0 nz_x25 nz_e15 0 -0.0026122100635195627
Cnz_x26 nz_x26 0 1.5871725736917026e-13
Gnz_a26_26 0 nz_x26 nz_x26 0 -0.4303434682550038
Gnz_k26_1 0 nz_x26 nz_e1 0 0.06657784744397938
Gnz_k26_2 0 nz_x26 nz_e2 0 0.029317420392387078
Gnz_k26_3 0 nz_x26 nz_e3 0 -0.3288618543418661
Gnz_k26_4 0 nz_x26 nz_e4 0 -0.27145006912302017
Gnz_k26_5 0 nz_x26 nz_e5 0 0.3386620287119621
Gnz_k26_6 0 nz_x26 nz_e6 0 0.0017661412964280825
Gnz_k26_7 0 nz_x26 nz_e7 0 -0.002184125620506679
Gnz_k26_8 0 nz_x26 nz_e8 0 -0.0014994658019161502
Gnz_k26_9 0 nz_x26 nz_e9 0 0.001498561900961462
Gnz_k26_10 0 nz_x26 nz_e10 0 0.06450954245200059
Gnz_k26_11 0 nz_x26 nz_e11 0 -0.04278097986439044
Gnz_k26_12 0 nz_x26 nz_e12 0 -0.11105914633945854
Gnz_k26_13 0 nz_x26 nz_e13 0 0.00026904945013386924
Gnz_k26_14 0 nz_x26 nz_e14 0 -0.0006569655313884049
Gnz_k26_15 0 nz_x26 nz_e15 0 -0.0005716835492827
Cnz_x27 nz_x27 0 1.5871725736917026e-13
Gnz_a27_27 0 nz_x27 nz_x27 0 -0.0686021895257412
Gnz_a27_28 0 nz_x27 nz_x28 0 0.19970950744058633
Gnz_k27_1 0 nz_x27 nz_e1 0 0.007614044535488355
Gnz_k27_2 0 nz_x27 nz_e2 0 0.00449326425648361
Gnz_k27_3 0 nz_x27 nz_e3 0 -0.031914568209181
Gnz_k27_4 0 nz_x27 nz_e4 0 -0.03102714381223554
Gnz_k27_5 0 nz_x27 nz_e5 0 0.024355032885549764
Gnz_k27_6 0 nz_x27 nz_e6 0 0.00018786865116703053
Gnz_k27_7 0 nz_x27 nz_e7 0 -0.0002420406771628537
Gnz_k27_8 0 nz_x27 nz_e8 0 6.674386768445147e-08
Gnz_k27_9 0 nz_x27 nz_e9 0 0.00014040469204798246
Gnz_k27_10 0 nz_x27 nz_e10 0 0.0056451055844520615
Gnz_k27_11 0 nz_x27 nz_e11 0 -0.003555804799280195
Gnz_k27_12 0 nz_x27 nz_e12 0 -0.007910418951705871
Gnz_k27_13 0 nz_x27 nz_e13 0 1.4907767373811446e-05
Gnz_k27_14 0 nz_x27 nz_e14 0 -0.00010050205489335304
Gnz_k27_15 0 nz_x27 nz_e15 0 -5.4691718675076476e-05
Cnz_x28 nz_x28 0 1.5871725736917026e-13
Gnz_a28_27 0 nz_x28 nz_x27 0 -0.19970950744058633
Gnz_a28_28 0 nz_x28 nz_x28 0 -0.0686021895257412
Gnz_k28_1 0 nz_x28 nz_e1 0 -0.0016137129967657004
Gnz_k28_2 0 nz_x28 nz_e2 0 -0.0010102936696462393
Gnz_k28_3 0 nz_x28 nz_e3 0 0.009651734750429153
Gnz_k28_4 0 nz_x28 nz_e4 0 0.013981013445159458
Gnz_k28_5 0 nz_x28 nz_e5 0 -0.00020631027570074971
Gnz_k28_6 0 nz_x28 nz_e6 0 0.00025918390426519404
Gnz_k28_7 0 nz_x28 nz_e7 0 8.963981461992302e-05
Gnz_k28_8 0 nz_x28 nz_e8 0 1.3692663307180399e-05
Gnz_k28_9 0 nz_x28 nz_e9 0 -6.48428017462556e-05
Gnz_k28_10 0 nz_x28 nz_e10 0 0.0016599349438488613
Gnz_k28_11 0 nz_x28 nz_e11 0 0.001192131064336529
Gnz_k28_12 0 nz_x28 nz_e12 0 0.0011844380963746206
Gnz_k28_13 0 nz_x28 nz_e13 0 1.4895314352869787e-05
Gnz_k28_14 0 nz_x28 nz_e14 0 0.00044141244455131375
Gnz_k28_15 0 nz_x28 nz_e15 0 -0.00047406168440704846
Cnz_x29 nz_x29 0 1.5871725736917026e-13
Gnz_a29_29 0 nz_x29 nz_x29 0 -0.012132536924247928
Gnz_k29_1 0 nz_x29 nz_e1 0 0.016873488536209607
Gnz_k29_2 0 nz_x29 nz_e2 0 0.020531973775596506
Gnz_k29_3 0 nz_x29 nz_e3 0 -0.05193621829633984
Gnz_k29_4 0 nz_x29 nz_e4 0 -0.06432694238777988
Gnz_k29_5 0 nz_x29 nz_e5 0 0.0204977606947148
Gnz_k29_6 0 nz_x29 nz_e6 0 -0.0006037341300372648
Gnz_k29_7 0 nz_x29 nz_e7 0 -0.0002814506492938249
Gnz_k29_8 0 nz_x29 nz_e8 0 4.915414131712388e-05
Gnz_k29_9 0 nz_x29 nz_e9 0 0.00014922352134198537
Gnz_k29_10 0 nz_x29 nz_e10 0 0.00010038274764265701
Gnz_k29_11 0 nz_x29 nz_e11 0 -0.003175437219908797
Gnz_k29_12 0 nz_x29 nz_e12 0 -0.0006175426029793701
Gnz_k29_13 0 nz_x29 nz_e13 0 5.823603001964265e-05
Gnz_k29_14 0 nz_x29 nz_e14 0 -0.0011841315495181907
Gnz_k29_15 0 nz_x29 nz_e15 0 0.0009565739188085142
Cnz_x30 nz_x30 0 1.5871725736917026e-13
Gnz_a30_30 0 nz_x30 nz_x30 0 -0.19573736862898244
Gnz_k30_1 0 nz_x30 nz_e1 0 0.07896767916484092
Gnz_k30_2 0 nz_x30 nz_e2 0 0.05048080517810879
Gnz_k30_3 0 nz_x30 nz_e3 0 -0.33682780546616375
Gnz_k30_4 0 nz_x30 nz_e4 0 -0.32358270645130954
Gnz_k30_5 0 nz_x30 nz_e5 0 0.26941240713340386
Gnz_k30_6 0 nz_x30 nz_e6 0 0.0004388763192287597
Gnz_k30_7 0 nz_x30 nz_e7 0 -0.0020346138537829356
Gnz_k30_8 0 nz_x30 nz_e8 0 -0.0007138100971408666
Gnz_k30_9 0 nz_x30 nz_e9 0 0.0009495349733604533
Gnz_k30_10 0 nz_x30 nz_e10 0 0.04838109774480528
Gnz_k30_11 0 nz_x30 nz_e11 0 -0.03975414957202857
Gnz_k30_12 0 nz_x30 nz_e12 0 -0.08253493189695817
Gnz_k30_13 0 nz_x30 nz_e13 0 0.0004428683623600706
Gnz_k30_14 0 nz_x30 nz_e14 0 -0.00247238995920666
Gnz_k30_15 0 nz_x30 nz_e15 0 0.0012891569543143021
Cnz_x31 nz_x31 0 1.5871725736917026e-13
Gnz_a31_31 0 nz_x31 nz_x31 0 -1.0
Gnz_k31_1 0 nz_x31 nz_e1 0 0.002547688841337814
Gnz_k31_2 0 nz_x31 nz_e2 0 0.0005972620934777664
Gnz_k31_3 0 nz_x31 nz_e3 0 -0.00040858521016909685
Gnz_k31_4 0 nz_x31 nz_e4 0 -0.0008303643624384557
Gnz_k31_5 0 nz_x31 nz_e5 0 -0.0009197721381770873
Gnz_k31_6 0 nz_x31 nz_e6 0 -0.40995098778340905
Gnz_k31_7 0 nz_x31 nz_e7 0 -0.2826323082660023
Gnz_k31_8 0 nz_x31 nz_e8 0 -0.05968460895023526
Gnz_k31_9 0 nz_x31 nz_e9 0 0.037337995841626365
Gnz_k31_10 0 nz_x31 nz_e10 0 -0.0011482118239017993
Gnz_k31_11 0 nz_x31 nz_e11 0 0.0009666706208578608
Gnz_k31_12 0 nz_x31 nz_e12 0 0.0026196721232892655
Gnz_k31_13 0 nz_x31 nz_e13 0 0.055864701296814256
Gnz_k31_14 0 nz_x31 nz_e14 0 -0.051666525994589034
Gnz_k31_15 0 nz_x31 nz_e15 0 -0.3267449193998661
Cnz_x32 nz_x32 0 1.5871725736917026e-13
Gnz_a32_32 0 nz_x32 nz_x32 0 -0.4303434682550038
Gnz_k32_1 0 nz_x32 nz_e1 0 0.0018338368380521948
Gnz_k32_2 0 nz_x32 nz_e2 0 0.000481540980193861
Gnz_k32_3 0 nz_x32 nz_e3 0 -0.0004956622962651553
Gnz_k32_4 0 nz_x32 nz_e4 0 0.00010622177631012028
Gnz_k32_5 0 nz_x32 nz_e5 0 -0.00102208814214353
Gnz_k32_6 0 nz_x32 nz_e6 0 -0.2825859111468469
Gnz_k32_7 0 nz_x32 nz_e7 0 -0.14480988410298262
Gnz_k32_8 0 nz_x32 nz_e8 0 -0.02993971405620097
Gnz_k32_9 0 nz_x32 nz_e9 0 0.021450047531643545
Gnz_k32_10 0 nz_x32 nz_e10 0 -0.000236639915388519
Gnz_k32_11 0 nz_x32 nz_e11 0 0.0008308879923374531
Gnz_k32_12 0 nz_x32 nz_e12 0 0.0012989684818098756
Gnz_k32_13 0 nz_x32 nz_e13 0 0.028977693381407356
Gnz_k32_14 0 nz_x32 nz_e14 0 -0.028665092064951624
Gnz_k32_15 0 nz_x32 nz_e15 0 -0.18473361200298427
Cnz_x33 nz_x33 0 1.5871725736917026e-13
Gnz_a33_33 0 nz_x33 nz_x33 0 -0.06860218952574121
Gnz_a33_34 0 nz_x33 nz_x34 0 0.19970950744058633
Gnz_k33_1 0 nz_x33 nz_e1 0 6.692404602518999e-05
Gnz_k33_2 0 nz_x33 nz_e2 0 1.2926866784437455e-05
Gnz_k33_3 0 nz_x33 nz_e3 0 3.99719771879863e-05
Gnz_k33_4 0 nz_x33 nz_e4 0 2.3867060205890468e-05
Gnz_k33_5 0 nz_x33 nz_e5 0 -2.5425341904825145e-05
Gnz_k33_6 0 nz_x33 nz_e6 0 -0.037730950522316765
Gnz_k33_7 0 nz_x33 nz_e7 0 -0.023787753746911246
Gnz_k33_8 0 nz_x33 nz_e8 0 -0.008175556814201648
Gnz_k33_9 0 nz_x33 nz_e9 0 0.0032261597439653253
Gnz_k33_10 0 nz_x33 nz_e10 0 -3.75736622117885e-05
Gnz_k33_11 0 nz_x33 nz_e11 0 0.0001541042139523903
Gnz_k33_12 0 nz_x33 nz_e12 0 0.0004982026456483548
Gnz_k33_13 0 nz_x33 nz_e13 0 0.0058303989277058415
Gnz_k33_14 0 nz_x33 nz_e14 0 -0.007662899802441578
Gnz_k33_15 0 nz_x33 nz_e15 0 -0.01096030039872052
Cnz_x34 nz_x34 0 1.5871725736917026e-13
Gnz_a34_33 0 nz_x34 nz_x33 0 -0.19970950744058633
Gnz_a34_34 0 nz_x34 nz_x34 0 -0.06860218952574121
Gnz_k34_1 0 nz_x34 nz_e1 0 -0.0006796199152301441
Gnz_k34_2 0 nz_x34 nz_e2 0 -0.00014226535806039514
Gnz_k34_3 0 nz_x34 nz_e3 0 0.0003418169183466463
Gnz_k34_4 0 nz_x34 nz_e4 0 5.831901586382051e-05
Gnz_k34_5 0 nz_x34 nz_e5 0 0.00034024725022911787
Gnz_k34_6 0 nz_x34 nz_e6 0 0.1085797200929077
Gnz_k34_7 0 nz_x34 nz_e7 0 0.03569039508170719
Gnz_k34_8 0 nz_x34 nz_e8 0 0.003714726871853499
Gnz_k34_9 0 nz_x34 nz_e9 0 -0.005794169237258277
Gnz_k34_10 0 nz_x34 nz_e10 0 -3.591586910654369e-05
Gnz_k34_11 0 nz_x34 nz_e11 0 -0.00022691699936334264
Gnz_k34_12 0 nz_x34 nz_e12 0 4.4024008726305916e-05
Gnz_k34_13 0 nz_x34 nz_e13 0 -0.0066772349470880805
Gnz_k34_14 0 nz_x34 nz_e14 0 0.004515298083938772
Gnz_k34_15 0 nz_x34 nz_e15 0 0.06620020484080942
Cnz_x35 nz_x35 0 1.5871725736917026e-13
Gnz_a35_35 0 nz_x35 nz_x35 0 -0.012132536924247928
Gnz_k35_1 0 nz_x35 nz_e1 0 0.0013676150290136471
Gnz_k35_2 0 nz_x35 nz_e2 0 0.000348112439885713
Gnz_k35_3 0 nz_x35 nz_e3 0 -0.0005814628306814908
Gnz_k35_4 0 nz_x35 nz_e4 0 0.00018559599905021613
Gnz_k35_5 0 nz_x35 nz_e5 0 -0.0007103352736739988
Gnz_k35_6 0 nz_x35 nz_e6 0 -0.13649172832921969
Gnz_k35_7 0 nz_x35 nz_e7 0 -0.04742124121389974
Gnz_k35_8 0 nz_x35 nz_e8 0 -0.002924538781003519
Gnz_k35_9 0 nz_x35 nz_e9 0 0.012440672786491086
Gnz_k35_10 0 nz_x35 nz_e10 0 -0.00017625646588349166
Gnz_k35_11 0 nz_x35 nz_e11 0 -9.208964246745157e-05
Gnz_k35_12 0 nz_x35 nz_e12 0 -0.0005469895094735469
Gnz_k35_13 0 nz_x35 nz_e13 0 0.010630533896246469
Gnz_k35_14 0 nz_x35 nz_e14 0 -0.005092316539536948
Gnz_k35_15 0 nz_x35 nz_e15 0 -0.0880510363100511
Cnz_x36 nz_x36 0 1.5871725736917026e-13
Gnz_a36_36 0 nz_x36 nz_x36 0 -0.19573736862898244
Gnz_k36_1 0 nz_x36 nz_e1 0 0.0007705309862875341
Gnz_k36_2 0 nz_x36 nz_e2 0 0.0001892756241841183
Gnz_k36_3 0 nz_x36 nz_e3 0 -0.00024993378267779365
Gnz_k36_4 0 nz_x36 nz_e4 0 7.33643049747401e-05
Gnz_k36_5 0 nz_x36 nz_e5 0 -0.00044282468299087097
Gnz_k36_6 0 nz_x36 nz_e6 0 -0.11231987075350257
Gnz_k36_7 0 nz_x36 nz_e7 0 -0.04633773341162035
Gnz_k36_8 0 nz_x36 nz_e8 0 -0.007912209968659496
Gnz_k36_9 0 nz_x36 nz_e9 0 0.007454180193792314
Gnz_k36_10 0 nz_x36 nz_e10 0 -4.362239513656993e-05
Gnz_k36_11 0 nz_x36 nz_e11 0 0.0003475261897528574
Gnz_k36_12 0 nz_x36 nz_e12 0 0.00023488809893313782
Gnz_k36_13 0 nz_x36 nz_e13 0 0.009028481018548726
Gnz_k36_14 0 nz_x36 nz_e14 0 -0.00829252775720526
Gnz_k36_15 0 nz_x36 nz_e15 0 -0.0703657455057035
Cnz_x37 nz_x37 0 1.5871725736917026e-13
Gnz_a37_37 0 nz_x37 nz_x37 0 -1.0
Gnz_k37_1 0 nz_x37 nz_e1 0 -0.0018699995902951808
Gnz_k37_2 0 nz_x37 nz_e2 0 0.00018294231923052308
Gnz_k37_3 0 nz_x37 nz_e3 0 -0.0004296415077269448
Gnz_k37_4 0 nz_x37 nz_e4 0 0.00029073400566488687
Gnz_k37_5 0 nz_x37 nz_e5 0 -0.0006866503292513463
Gnz_k37_6 0 nz_x37 nz_e6 0 -0.27489775412699574
Gnz_k37_7 0 nz_x37 nz_e7 0 -0.5079346532363089
Gnz_k37_8 0 nz_x37 nz_e8 0 0.10850505783156864
Gnz_k37_9 0 nz_x37 nz_e9 0 -0.24273292694624596
Gnz_k37_10 0 nz_x37 nz_e10 0 0.0009371084132304812
Gnz_k37_11 0 nz_x37 nz_e11 0 -0.0007152968633904697
Gnz_k37_12 0 nz_x37 nz_e12 0 -0.0004812778144168756
Gnz_k37_13 0 nz_x37 nz_e13 0 -0.31427569280627055
Gnz_k37_14 0 nz_x37 nz_e14 0 0.07129165033462637
Gnz_k37_15 0 nz_x37 nz_e15 0 0.14870477777801697
Cnz_x38 nz_x38 0 1.5871725736917026e-13
Gnz_a38_38 0 nz_x38 nz_x38 0 -0.4303434682550038
Gnz_k38_1 0 nz_x38 nz_e1 0 -0.001082535508718645
Gnz_k38_2 0 nz_x38 nz_e2 0 0.00019434376262890174
Gnz_k38_3 0 nz_x38 nz_e3 0 0.00011152789861134074
Gnz_k38_4 0 nz_x38 nz_e4 0 -1.117948140130312e-06
Gnz_k38_5 0 nz_x38 nz_e5 0 -0.00017596244410229283
Gnz_k38_6 0 nz_x38 nz_e6 0 -0.11457073519058673
Gnz_k38_7 0 nz_x38 nz_e7 0 -0.30375634797506873
Gnz_k38_8 0 nz_x38 nz_e8 0 0.05505627681986369
Gnz_k38_9 0 nz_x38 nz_e9 0 -0.11732270724641548
Gnz_k38_10 0 nz_x38 nz_e10 0 -0.00027561297451864786
Gnz_k38_11 0 nz_x38 nz_e11 0 -0.00025389330298428506
Gnz_k38_12 0 nz_x38 nz_e12 0 3.3473555954541074e-05
Gnz_k38_13 0 nz_x38 nz_e13 0 -0.15359116555536242
Gnz_k38_14 0 nz_x38 nz_e14 0 0.03506708902855108
Gnz_k38_15 0 nz_x38 nz_e15 0 0.06516278362350478
Cnz_x39 nz_x39 0 1.5871725736917026e-13
Gnz_a39_39 0 nz_x39 nz_x39 0 -0.06860218952574121
Gnz_a39_40 0 nz_x39 nz_x40 0 0.19970950744058633
Gnz_k39_1 0 nz_x39 nz_e1 0 -0.0001798564173753814
Gnz_k39_2 0 nz_x39 nz_e2 0 6.385973064050093e-05
Gnz_k39_3 0 nz_x39 nz_e3 0 -0.00012536229096148368
Gnz_k39_4 0 nz_x39 nz_e4 0 3.261090179207919e-05
Gnz_k39_5 0 nz_x39 nz_e5 0 -9.439172528134969e-05
Gnz_k39_6 0 nz_x39 nz_e6 0 -0.019109622536322715
Gnz_k39_7 0 nz_x39 nz_e7 0 -0.04027808379659902
Gnz_k39_8 0 nz_x39 nz_e8 0 0.004972823673516493
Gnz_k39_9 0 nz_x39 nz_e9 0 -0.007398379393609582
Gnz_k39_10 0 nz_x39 nz_e10 0 -8.853445985864157e-05
Gnz_k39_11 0 nz_x39 nz_e11 0 0.00017493815884887424
Gnz_k39_12 0 nz_x39 nz_e12 0 0.00014527210672188122
Gnz_k39_13 0 nz_x39 nz_e13 0 -0.00782741297744379
Gnz_k39_14 0 nz_x39 nz_e14 0 0.006198633745143631
Gnz_k39_15 0 nz_x39 nz_e15 0 0.013183411724184382
Cnz_x40 nz_x40 0 1.5871725736917026e-13
Gnz_a40_39 0 nz_x40 nz_x39 0 -0.19970950744058633
Gnz_a40_40 0 nz_x40 nz_x40 0 -0.06860218952574121
Gnz_k40_1 0 nz_x40 nz_e1 0 0.0002434449988601609
Gnz_k40_2 0 nz_x40 nz_e2 0 -9.996979649829632e-05
Gnz_k40_3 0 nz_x40 nz_e3 0 -0.0002066983051386228
Gnz_k40_4 0 nz_x40 nz_e4 0 -0.000159541854382203
Gnz_k40_5 0 nz_x40 nz_e5 0 7.90600990699137e-05
Gnz_k40_6 0 nz_x40 nz_e6 0 0.02260327525299886
Gnz_k40_7 0 nz_x40 nz_e7 0 0.10891244192751695
Gnz_k40_8 0 nz_x40 nz_e8 0 -0.018487007277635286
Gnz_k40_9 0 nz_x40 nz_e9 0 0.03861734080468963
Gnz_k40_10 0 nz_x40 nz_e10 0 0.00014802897097039165
Gnz_k40_11 0 nz_x40 nz_e11 0 0.00030805397283166286
Gnz_k40_12 0 nz_x40 nz_e12 0 -5.4196125705980084e-05
Gnz_k40_13 0 nz_x40 nz_e13 0 0.05172532954400606
Gnz_k40_14 0 nz_x40 nz_e14 0 -0.009850453717357108
Gnz_k40_15 0 nz_x40 nz_e15 0 -0.012086499813405495
Cnz_x41 nz_x41 0 1.5871725736917026e-13
Gnz_a41_41 0 nz_x41 nz_x41 0 -0.012132536924247928
Gnz_k41_1 0 nz_x41 nz_e1 0 2.3130680975377877e-06
Gnz_k41_2 0 nz_x41 nz_e2 0 0.00017166862439710602
Gnz_k41_3 0 nz_x41 nz_e3 0 0.00041922101288730147
Gnz_k41_4 0 nz_x41 nz_e4 0 -5.715109019276684e-05
Gnz_k41_5 0 nz_x41 nz_e5 0 -0.0002785100053864188
Gnz_k41_6 0 nz_x41 nz_e6 0 -0.030215127498903618
Gnz_k41_7 0 nz_x41 nz_e7 0 -0.14141327188627836
Gnz_k41_8 0 nz_x41 nz_e8 0 0.033076121715448076
Gnz_k41_9 0 nz_x41 nz_e9 0 -0.035099678880662843
Gnz_k41_10 0 nz_x41 nz_e10 0 -0.002249294621867393
Gnz_k41_11 0 nz_x41 nz_e11 0 -0.001416260533242207
Gnz_k41_12 0 nz_x41 nz_e12 0 -0.00020044921521476393
Gnz_k41_13 0 nz_x41 nz_e13 0 -0.05936911486751761
Gnz_k41_14 0 nz_x41 nz_e14 0 0.015014891790818411
Gnz_k41_15 0 nz_x41 nz_e15 0 0.021664355235182432
Cnz_x42 nz_x42 0 1.5871725736917026e-13
Gnz_a42_42 0 nz_x42 nz_x42 0 -0.19573736862898244
Gnz_k42_1 0 nz_x42 nz_e1 0 -0.00033926047365489534
Gnz_k42_2 0 nz_x42 nz_e2 0 0.00010140771267288467
Gnz_k42_3 0 nz_x42 nz_e3 0 0.00010141256342008696
Gnz_k42_4 0 nz_x42 nz_e4 0 3.8420292016938945e-05
Gnz_k42_5 0 nz_x42 nz_e5 0 -7.012874819703767e-05
Gnz_k42_6 0 nz_x42 nz_e6 0 -0.03257227170181468
Gnz_k42_7 0 nz_x42 nz_e7 0 -0.11441374737527919
Gnz_k42_8 0 nz_x42 nz_e8 0 0.020280519691746
Gnz_k42_9 0 nz_x42 nz_e9 0 -0.04136729710716667
Gnz_k42_10 0 nz_x42 nz_e10 0 -0.00016738411013680283
Gnz_k42_11 0 nz_x42 nz_e11 0 -0.00021528899456703875
Gnz_k42_12 0 nz_x42 nz_e12 0 7.827677744130093e-06
Gnz_k42_13 0 nz_x42 nz_e13 0 -0.05555482422842754
Gnz_k42_14 0 nz_x42 nz_e14 0 0.011635169405570954
Gnz_k42_15 0 nz_x42 nz_e15 0 0.01837371096476062
Cnz_x43 nz_x43 0 1.5871725736917026e-13
Gnz_a43_43 0 nz_x43 nz_x43 0 -1.0
Gnz_k43_1 0 nz_x43 nz_e1 0 0.0003944486503552972
Gnz_k43_2 0 nz_x43 nz_e2 0 -0.0007300912805758012
Gnz_k43_3 0 nz_x43 nz_e3 0 0.0009241869886506234
Gnz_k43_4 0 nz_x43 nz_e4 0 -0.004780293677179587
Gnz_k43_5 0 nz_x43 nz_e5 0 -0.00022545473939747718
Gnz_k43_6 0 nz_x43 nz_e6 0 -0.14979836237847316
Gnz_k43_7 0 nz_x43 nz_e7 0 0.18825969023073183
Gnz_k43_8 0 nz_x43 nz_e8 0 -0.4408059774745489
Gnz_k43_9 0 nz_x43 nz_e9 0 -0.4844048196066706
Gnz_k43_10 0 nz_x43 nz_e10 0 -0.008480792641361694
Gnz_k43_11 0 nz_x43 nz_e11 0 0.005538064579723276
Gnz_k43_12 0 nz_x43 nz_e12 0 0.005004850509376916
Gnz_k43_13 0 nz_x43 nz_e13 0 0.14713852712993675
Gnz_k43_14 0 nz_x43 nz_e14 0 -0.11894683997071227
Gnz_k43_15 0 nz_x43 nz_e15 0 0.13367988087928484
Cnz_x44 nz_x44 0 1.5871725736917026e-13
Gnz_a44_44 0 nz_x44 nz_x44 0 -0.4303434682550038
Gnz_k44_1 0 nz_x44 nz_e1 0 -0.0007473161834692328
Gnz_k44_2 0 nz_x44 nz_e2 0 -0.00017321732987652869
Gnz_k44_3 0 nz_x44 nz_e3 0 0.002280307860257033
Gnz_k44_4 0 nz_x44 nz_e4 0 -0.004961514363258248
Gnz_k44_5 0 nz_x44 nz_e5 0 0.002139918123019886
Gnz_k44_6 0 nz_x44 nz_e6 0 -0.10427419018696207
Gnz_k44_7 0 nz_x44 nz_e7 0 0.13645955906113275
Gnz_k44_8 0 nz_x44 nz_e8 0 -0.33777619553048827
Gnz_k44_9 0 nz_x44 nz_e9 0 -0.32265888894305156
Gnz_k44_10 0 nz_x44 nz_e10 0 -0.008778221654404937
Gnz_k44_11 0 nz_x44 nz_e11 0 0.007263391942482902
Gnz_k44_12 0 nz_x44 nz_e12 0 0.004204102212918025
Gnz_k44_13 0 nz_x44 nz_e13 0 0.1052528622948131
Gnz_k44_14 0 nz_x44 nz_e14 0 -0.0845681371992243
Gnz_k44_15 0 nz_x44 nz_e15 0 0.0924148206565254
Cnz_x45 nz_x45 0 1.5871725736917026e-13
Gnz_a45_45 0 nz_x45 nz_x45 0 -0.0686021895257412
Gnz_a45_46 0 nz_x45 nz_x46 0 0.19970950744058633
Gnz_k45_1 0 nz_x45 nz_e1 0 0.0005268010941797259
Gnz_k45_2 0 nz_x45 nz_e2 0 0.0004994934854721336
Gnz_k45_3 0 nz_x45 nz_e3 0 0.000574307497552772
Gnz_k45_4 0 nz_x45 nz_e4 0 -0.0001650374766970215
Gnz_k45_5 0 nz_x45 nz_e5 0 9.934160579164601e-05
Gnz_k45_6 0 nz_x45 nz_e6 0 -0.02852830248134857
Gnz_k45_7 0 nz_x45 nz_e7 0 0.020926016490473622
Gnz_k45_8 0 nz_x45 nz_e8 0 -0.06593095557268898
Gnz_k45_9 0 nz_x45 nz_e9 0 -0.05179918325911761
Gnz_k45_10 0 nz_x45 nz_e10 0 -0.0019761441838803944
Gnz_k45_11 0 nz_x45 nz_e11 0 0.00037684677152637167
Gnz_k45_12 0 nz_x45 nz_e12 0 0.0006829764512126131
Gnz_k45_13 0 nz_x45 nz_e13 0 0.019367466373823833
Gnz_k45_14 0 nz_x45 nz_e14 0 -0.023504901650024942
Gnz_k45_15 0 nz_x45 nz_e15 0 0.02494091995594681
Cnz_x46 nz_x46 0 1.5871725736917026e-13
Gnz_a46_45 0 nz_x46 nz_x45 0 -0.19970950744058633
Gnz_a46_46 0 nz_x46 nz_x46 0 -0.0686021895257412
Gnz_k46_1 0 nz_x46 nz_e1 0 0.00015366786577718426
Gnz_k46_2 0 nz_x46 nz_e2 0 -0.0003624805350620881
Gnz_k46_3 0 nz_x46 nz_e3 0 0.0006863687495640661
Gnz_k46_4 0 nz_x46 nz_e4 0 0.0021518961046787526
Gnz_k46_5 0 nz_x46 nz_e5 0 -0.0008462088843804834
Gnz_k46_6 0 nz_x46 nz_e6 0 0.021713967457842535
Gnz_k46_7 0 nz_x46 nz_e7 0 -0.046564934648177056
Gnz_k46_8 0 nz_x46 nz_e8 0 0.11780581574236502
Gnz_k46_9 0 nz_x46 nz_e9 0 0.09857537070649268
Gnz_k46_10 0 nz_x46 nz_e10 0 0.0007237458156762504
Gnz_k46_11 0 nz_x46 nz_e11 0 -0.0027302320732657914
Gnz_k46_12 0 nz_x46 nz_e12 0 -4.675064670221227e-06
Gnz_k46_13 0 nz_x46 nz_e13 0 -0.03287968834796677
Gnz_k46_14 0 nz_x46 nz_e14 0 0.01454080517100181
Gnz_k46_15 0 nz_x46 nz_e15 0 -0.019200429740674024
Cnz_x47 nz_x47 0 1.5871725736917026e-13
Gnz_a47_47 0 nz_x47 nz_x47 0 -0.012132536924247928
Gnz_k47_1 0 nz_x47 nz_e1 0 -0.010108494224276128
Gnz_k47_2 0 nz_x47 nz_e2 0 -0.0026464940241742157
Gnz_k47_3 0 nz_x47 nz_e3 0 0.004952004643346315
Gnz_k47_4 0 nz_x47 nz_e4 0 -0.01068894260164434
Gnz_k47_5 0 nz_x47 nz_e5 0 0.008845815364844831
Gnz_k47_6 0 nz_x47 nz_e6 0 -0.01690276107685628
Gnz_k47_7 0 nz_x47 nz_e7 0 0.08593557322852614
Gnz_k47_8 0 nz_x47 nz_e8 0 -0.17231266142356413
Gnz_k47_9 0 nz_x47 nz_e9 0 -0.15854201778073757
Gnz_k47_10 0 nz_x47 nz_e10 0 -0.0013733214228149459
Gnz_k47_11 0 nz_x47 nz_e11 0 0.013915882707030716
Gnz_k47_12 0 nz_x47 nz_e12 0 0.0015743932170655922
Gnz_k47_13 0 nz_x47 nz_e13 0 0.05140883894770171
Gnz_k47_14 0 nz_x47 nz_e14 0 -0.0078157673662847
Gnz_k47_15 0 nz_x47 nz_e15 0 0.007273709762232242
Cnz_x48 nz_x48 0 1.5871725736917026e-13
Gnz_a48_48 0 nz_x48 nz_x48 0 -0.19573736862898244
Gnz_k48_1 0 nz_x48 nz_e1 0 -0.000553788912935521
Gnz_k48_2 0 nz_x48 nz_e2 0 1.2375166381049098e-05
Gnz_k48_3 0 nz_x48 nz_e3 0 0.0006667340447405115
Gnz_k48_4 0 nz_x48 nz_e4 0 -0.0023892737636002767
Gnz_k48_5 0 nz_x48 nz_e5 0 0.0012171205650965272
Gnz_k48_6 0 nz_x48 nz_e6 0 -0.03464094972458317
Gnz_k48_7 0 nz_x48 nz_e7 0 0.05517921972303626
Gnz_k48_8 0 nz_x48 nz_e8 0 -0.1368879036348845
Gnz_k48_9 0 nz_x48 nz_e9 0 -0.12225149900874574
Gnz_k48_10 0 nz_x48 nz_e10 0 -0.002953356985053449
Gnz_k48_11 0 nz_x48 nz_e11 0 0.0034442783491606967
Gnz_k48_12 0 nz_x48 nz_e12 0 0.0011588678076060205
Gnz_k48_13 0 nz_x48 nz_e13 0 0.040221992847899735
Gnz_k48_14 0 nz_x48 nz_e14 0 -0.02686229081083866
Gnz_k48_15 0 nz_x48 nz_e15 0 0.030332141708392536
Cnz_x49 nz_x49 0 1.5871725736917026e-13
Gnz_a49_49 0 nz_x49 nz_x49 0 -1.0
Gnz_k49_1 0 nz_x49 nz_e1 0 0.00034008819034688246
Gnz_k49_2 0 nz_x49 nz_e2 0 0.001501139709185818
Gnz_k49_3 0 nz_x49 nz_e3 0 0.0006028844841643753
Gnz_k49_4 0 nz_x49 nz_e4 0 8.322826279991983e-05
Gnz_k49_5 0 nz_x49 nz_e5 0 0.0020830372214633718
Gnz_k49_6 0 nz_x49 nz_e6 0 0.1297097744071899
Gnz_k49_7 0 nz_x49 nz_e7 0 -0.20083400870386034
Gnz_k49_8 0 nz_x49 nz_e8 0 -0.3128560603605668
Gnz_k49_9 0 nz_x49 nz_e9 0 -0.567042576089569
Gnz_k49_10 0 nz_x49 nz_e10 0 -0.0018270446588483798
Gnz_k49_11 0 nz_x49 nz_e11 0 0.0009602617599011775
Gnz_k49_12 0 nz_x49 nz_e12 0 0.005216811937882255
Gnz_k49_13 0 nz_x49 nz_e13 0 -0.34638576606255334
Gnz_k49_14 0 nz_x49 nz_e14 0 0.0804335500310106
Gnz_k49_15 0 nz_x49 nz_e15 0 -0.10874242488694441
Cnz_x50 nz_x50 0 1.5871725736917026e-13
Gnz_a50_50 0 nz_x50 nz_x50 0 -0.4303434682550038
Gnz_k50_1 0 nz_x50 nz_e1 0 0.0006330991091977678
Gnz_k50_2 0 nz_x50 nz_e2 0 0.0006492736659874453
Gnz_k50_3 0 nz_x50 nz_e3 0 -0.0003586829289906377
Gnz_k50_4 0 nz_x50 nz_e4 0 0.0006891454754754312
Gnz_k50_5 0 nz_x50 nz_e5 0 0.0006205843667192024
Gnz_k50_6 0 nz_x50 nz_e6 0 0.08399011550212536
Gnz_k50_7 0 nz_x50 nz_e7 0 -0.11278317577052949
Gnz_k50_8 0 nz_x50 nz_e8 0 -0.18270844664185878
Gnz_k50_9 0 nz_x50 nz_e9 0 -0.4149252066735681
Gnz_k50_10 0 nz_x50 nz_e10 0 0.0011540568680155506
Gnz_k50_11 0 nz_x50 nz_e11 0 -0.00022598569288259486
Gnz_k50_12 0 nz_x50 nz_e12 0 0.0023134726861293283
Gnz_k50_13 0 nz_x50 nz_e13 0 -0.21615577115477272
Gnz_k50_14 0 nz_x50 nz_e14 0 0.05450879309001523
Gnz_k50_15 0 nz_x50 nz_e15 0 -0.06927437470690068
Cnz_x51 nz_x51 0 1.5871725736917026e-13
Gnz_a51_51 0 nz_x51 nz_x51 0 -0.0686021895257412
Gnz_a51_52 0 nz_x51 nz_x52 0 0.19970950744058633
Gnz_k51_1 0 nz_x51 nz_e1 0 0.0004543995664004278
Gnz_k51_2 0 nz_x51 nz_e2 0 0.00026385742975416774
Gnz_k51_3 0 nz_x51 nz_e3 0 7.899554025638255e-06
Gnz_k51_4 0 nz_x51 nz_e4 0 0.00039485396064312556
Gnz_k51_5 0 nz_x51 nz_e5 0 3.5123828293121485e-05
Gnz_k51_6 0 nz_x51 nz_e6 0 0.01289322520365437
Gnz_k51_7 0 nz_x51 nz_e7 0 -0.004659627601453801
Gnz_k51_8 0 nz_x51 nz_e8 0 -0.02744798621696623
Gnz_k51_9 0 nz_x51 nz_e9 0 -0.05719805264835724
Gnz_k51_10 0 nz_x51 nz_e10 0 -0.00012989148857061624
Gnz_k51_11 0 nz_x51 nz_e11 0 -0.0006930080321730801
Gnz_k51_12 0 nz_x51 nz_e12 0 0.00016775922514060447
Gnz_k51_13 0 nz_x51 nz_e13 0 -0.01547143166769776
Gnz_k51_14 0 nz_x51 nz_e14 0 0.013569426186015211
Gnz_k51_15 0 nz_x51 nz_e15 0 -0.013001365108185486
Cnz_x52 nz_x52 0 1.5871725736917026e-13
Gnz_a52_51 0 nz_x52 nz_x51 0 -0.19970950744058633
Gnz_a52_52 0 nz_x52 nz_x52 0 -0.0686021895257412
Gnz_k52_1 0 nz_x52 nz_e1 0 0.00018380342927477126
Gnz_k52_2 0 nz_x52 nz_e2 0 -6.669724278735442e-05
Gnz_k52_3 0 nz_x52 nz_e3 0 0.0004575275583228637
Gnz_k52_4 0 nz_x52 nz_e4 0 0.0004013315620709989
Gnz_k52_5 0 nz_x52 nz_e5 0 -0.00037486909816860834
Gnz_k52_6 0 nz_x52 nz_e6 0 -0.026688697514068636
Gnz_k52_7 0 nz_x52 nz_e7 0 0.04081905952694234
Gnz_k52_8 0 nz_x52 nz_e8 0 0.05891640043361761
Gnz_k52_9 0 nz_x52 nz_e9 0 0.17006766404625878
Gnz_k52_10 0 nz_x52 nz_e10 0 -0.0014732614497824986
Gnz_k52_11 0 nz_x52 nz_e11 0 -0.0003408233595263257
Gnz_k52_12 0 nz_x52 nz_e12 0 -0.0003767052646028731
Gnz_k52_13 0 nz_x52 nz_e13 0 0.08373926254115108
Gnz_k52_14 0 nz_x52 nz_e14 0 -0.013810510834254408
Gnz_k52_15 0 nz_x52 nz_e15 0 0.020073954876900352
Cnz_x53 nz_x53 0 1.5871725736917026e-13
Gnz_a53_53 0 nz_x53 nz_x53 0 -0.012132536924247928
Gnz_k53_1 0 nz_x53 nz_e1 0 -0.001012821390730245
Gnz_k53_2 0 nz_x53 nz_e2 0 -0.00022335335081315197
Gnz_k53_3 0 nz_x53 nz_e3 0 -0.0010245758073440029
Gnz_k53_4 0 nz_x53 nz_e4 0 0.0002525342770986632
Gnz_k53_5 0 nz_x53 nz_e5 0 0.0010908177288273947
Gnz_k53_6 0 nz_x53 nz_e6 0 0.042169160949510606
Gnz_k53_7 0 nz_x53 nz_e7 0 -0.026293163318267088
Gnz_k53_8 0 nz_x53 nz_e8 0 -0.08567873597016738
Gnz_k53_9 0 nz_x53 nz_e9 0 -0.21911101290654436
Gnz_k53_10 0 nz_x53 nz_e10 0 0.006970813493593676
Gnz_k53_11 0 nz_x53 nz_e11 0 0.002862393416348445
Gnz_k53_12 0 nz_x53 nz_e12 0 0.00038121752565860035
Gnz_k53_13 0 nz_x53 nz_e13 0 -0.09013395381182754
Gnz_k53_14 0 nz_x53 nz_e14 0 0.023964621642684487
Gnz_k53_15 0 nz_x53 nz_e15 0 -0.03279727082925504
Cnz_x54 nz_x54 0 1.5871725736917026e-13
Gnz_a54_54 0 nz_x54 nz_x54 0 -0.19573736862898244
Gnz_k54_1 0 nz_x54 nz_e1 0 6.216142092470929e-05
Gnz_k54_2 0 nz_x54 nz_e2 0 0.00011871358754370972
Gnz_k54_3 0 nz_x54 nz_e3 0 -0.00023331784071950394
Gnz_k54_4 0 nz_x54 nz_e4 0 7.073502689560692e-05
Gnz_k54_5 0 nz_x54 nz_e5 0 0.0003249010847391749
Gnz_k54_6 0 nz_x54 nz_e6 0 0.03156896952109015
Gnz_k54_7 0 nz_x54 nz_e7 0 -0.04236700302738914
Gnz_k54_8 0 nz_x54 nz_e8 0 -0.0661921330032741
Gnz_k54_9 0 nz_x54 nz_e9 0 -0.1721237290453879
Gnz_k54_10 0 nz_x54 nz_e10 0 0.0009768673821612163
Gnz_k54_11 0 nz_x54 nz_e11 0 0.00010067119176452659
Gnz_k54_12 0 nz_x54 nz_e12 0 0.0006524841327420464
Gnz_k54_13 0 nz_x54 nz_e13 0 -0.08567373614033616
Gnz_k54_14 0 nz_x54 nz_e14 0 0.01887724215909522
Gnz_k54_15 0 nz_x54 nz_e15 0 -0.02488729001943212
Cnz_x55 nz_x55 0 1.5871725736917026e-13
Gnz_a55_55 0 nz_x55 nz_x55 0 -1.0
Gnz_k55_1 0 nz_x55 nz_e1 0 -0.004635821122006244
Gnz_k55_2 0 nz_x55 nz_e2 0 0.16471411196517594
Gnz_k55_3 0 nz_x55 nz_e3 0 -0.0507916050555314
Gnz_k55_4 0 nz_x55 nz_e4 0 -0.05962214556365414
Gnz_k55_5 0 nz_x55 nz_e5 0 0.04169674526042016
Gnz_k55_6 0 nz_x55 nz_e6 0 0.003609860036057536
Gnz_k55_7 0 nz_x55 nz_e7 0 -0.0048071441441059366
Gnz_k55_8 0 nz_x55 nz_e8 0 -0.011919844935486803
Gnz_k55_9 0 nz_x55 nz_e9 0 0.006063222548250246
Gnz_k55_10 0 nz_x55 nz_e10 0 0.28516285750735676
Gnz_k55_11 0 nz_x55 nz_e11 0 -0.4174611335974314
Gnz_k55_12 0 nz_x55 nz_e12 0 -0.6659014860630245
Gnz_k55_13 0 nz_x55 nz_e13 0 0.0005022604474456007
Gnz_k55_14 0 nz_x55 nz_e14 0 0.003016136718862955
Gnz_k55_15 0 nz_x55 nz_e15 0 -0.0019022751957607476
Cnz_x56 nz_x56 0 1.5871725736917026e-13
Gnz_a56_56 0 nz_x56 nz_x56 0 -0.4303434682550038
Gnz_k56_1 0 nz_x56 nz_e1 0 0.07534308124021229
Gnz_k56_2 0 nz_x56 nz_e2 0 0.11536672685549602
Gnz_k56_3 0 nz_x56 nz_e3 0 -0.05531540815411768
Gnz_k56_4 0 nz_x56 nz_e4 0 -0.04158124164128576
Gnz_k56_5 0 nz_x56 nz_e5 0 0.034896882482253914
Gnz_k56_6 0 nz_x56 nz_e6 0 0.0029748872857536233
Gnz_k56_7 0 nz_x56 nz_e7 0 -0.005181404818158939
Gnz_k56_8 0 nz_x56 nz_e8 0 -0.014764862989122243
Gnz_k56_9 0 nz_x56 nz_e9 0 0.0061206852512986736
Gnz_k56_10 0 nz_x56 nz_e10 0 0.005686649638796404
Gnz_k56_11 0 nz_x56 nz_e11 0 -0.4504518096733424
Gnz_k56_12 0 nz_x56 nz_e12 0 -0.38881098660159774
Gnz_k56_13 0 nz_x56 nz_e13 0 -0.0005442591793585357
Gnz_k56_14 0 nz_x56 nz_e14 0 0.0017753387446698464
Gnz_k56_15 0 nz_x56 nz_e15 0 -0.0022728933627338584
Cnz_x57 nz_x57 0 1.5871725736917026e-13
Gnz_a57_57 0 nz_x57 nz_x57 0 -0.0686021895257412
Gnz_a57_58 0 nz_x57 nz_x58 0 0.19970950744058633
Gnz_k57_1 0 nz_x57 nz_e1 0 0.007289864777623054
Gnz_k57_2 0 nz_x57 nz_e2 0 0.0036262113634782326
Gnz_k57_3 0 nz_x57 nz_e3 0 -0.0015087926818897893
Gnz_k57_4 0 nz_x57 nz_e4 0 -0.001115107939357942
Gnz_k57_5 0 nz_x57 nz_e5 0 0.0015846089404593497
Gnz_k57_6 0 nz_x57 nz_e6 0 2.011036859618826e-06
Gnz_k57_7 0 nz_x57 nz_e7 0 -0.00012623659929906396
Gnz_k57_8 0 nz_x57 nz_e8 0 -0.0007319030361244651
Gnz_k57_9 0 nz_x57 nz_e9 0 -4.998913873530767e-05
Gnz_k57_10 0 nz_x57 nz_e10 0 -0.009510409908853214
Gnz_k57_11 0 nz_x57 nz_e11 0 -0.027424678785083263
Gnz_k57_12 0 nz_x57 nz_e12 0 -0.01550509763617696
Gnz_k57_13 0 nz_x57 nz_e13 0 0.00010144045486480183
Gnz_k57_14 0 nz_x57 nz_e14 0 -2.8928052696692494e-05
Gnz_k57_15 0 nz_x57 nz_e15 0 -2.56141280406098e-05
Cnz_x58 nz_x58 0 1.5871725736917026e-13
Gnz_a58_57 0 nz_x58 nz_x57 0 -0.19970950744058633
Gnz_a58_58 0 nz_x58 nz_x58 0 -0.0686021895257412
Gnz_k58_1 0 nz_x58 nz_e1 0 -0.0025733675913830766
Gnz_k58_2 0 nz_x58 nz_e2 0 0.003449035237366365
Gnz_k58_3 0 nz_x58 nz_e3 0 0.001524862468724574
Gnz_k58_4 0 nz_x58 nz_e4 0 1.1647213672138433e-05
Gnz_k58_5 0 nz_x58 nz_e5 0 0.001269860186408729
Gnz_k58_6 0 nz_x58 nz_e6 0 0.00013785650971331127
Gnz_k58_7 0 nz_x58 nz_e7 0 0.00012008538031175972
Gnz_k58_8 0 nz_x58 nz_e8 0 0.0005048566421475315
Gnz_k58_9 0 nz_x58 nz_e9 0 -0.0001180765050767936
Gnz_k58_10 0 nz_x58 nz_e10 0 0.014030005782141291
Gnz_k58_11 0 nz_x58 nz_e11 0 0.017343546583828747
Gnz_k58_12 0 nz_x58 nz_e12 0 0.004486789184164308
Gnz_k58_13 0 nz_x58 nz_e13 0 1.8450384614667126e-05
Gnz_k58_14 0 nz_x58 nz_e14 0 0.000239630653856127
Gnz_k58_15 0 nz_x58 nz_e15 0 -0.00018873116625683255
Cnz_x59 nz_x59 0 1.5871725736917026e-13
Gnz_a59_59 0 nz_x59 nz_x59 0 -0.012132536924247928
Gnz_k59_1 0 nz_x59 nz_e1 0 0.0158603741051334
Gnz_k59_2 0 nz_x59 nz_e2 0 -0.021937682042109892
Gnz_k59_3 0 nz_x59 nz_e3 0 -0.013139123151253606
Gnz_k59_4 0 nz_x59 nz_e4 0 -0.014654628728147524
Gnz_k59_5 0 nz_x59 nz_e5 0 0.010620909157275055
Gnz_k59_6 0 nz_x59 nz_e6 0 0.004607802897816502
Gnz_k59_7 0 nz_x59 nz_e7 0 -0.007705616686890071
Gnz_k59_8 0 nz_x59 nz_e8 0 -0.011157189325454302
Gnz_k59_9 0 nz_x59 nz_e9 0 0.013283712889929893
Gnz_k59_10 0 nz_x59 nz_e10 0 -0.11826390262519845
Gnz_k59_11 0 nz_x59 nz_e11 0 -0.11475710091222019
Gnz_k59_12 0 nz_x59 nz_e12 0 -0.01839102643500448
Gnz_k59_13 0 nz_x59 nz_e13 0 -0.005090815156783056
Gnz_k59_14 0 nz_x59 nz_e14 0 0.0020479774467654813
Gnz_k59_15 0 nz_x59 nz_e15 0 -0.004402241925715921
Cnz_x60 nz_x60 0 1.5871725736917026e-13
Gnz_a60_60 0 nz_x60 nz_x60 0 -0.19573736862898244
Gnz_k60_1 0 nz_x60 nz_e1 0 0.06925286126465552
Gnz_k60_2 0 nz_x60 nz_e2 0 0.033831201786108565
Gnz_k60_3 0 nz_x60 nz_e3 0 -0.039360772454214724
Gnz_k60_4 0 nz_x60 nz_e4 0 -0.01795262029785179
Gnz_k60_5 0 nz_x60 nz_e5 0 0.014146727234949728
Gnz_k60_6 0 nz_x60 nz_e6 0 0.0010243685232050304
Gnz_k60_7 0 nz_x60 nz_e7 0 -0.0034857774926159366
Gnz_k60_8 0 nz_x60 nz_e8 0 -0.010591696478399418
Gnz_k60_9 0 nz_x60 nz_e9 0 0.003946254073844078
Gnz_k60_10 0 nz_x60 nz_e10 0 -0.10275507881512205
Gnz_k60_11 0 nz_x60 nz_e11 0 -0.31736715159226164
Gnz_k60_12 0 nz_x60 nz_e12 0 -0.18481010814010784
Gnz_k60_13 0 nz_x60 nz_e13 0 -0.0005902687919082637
Gnz_k60_14 0 nz_x60 nz_e14 0 -0.00013990530929883552
Gnz_k60_15 0 nz_x60 nz_e15 0 -0.0006588732986982429
Cnz_x61 nz_x61 0 1.5871725736917026e-13
Gnz_a61_61 0 nz_x61 nz_x61 0 -1.0
Gnz_k61_1 0 nz_x61 nz_e1 0 -0.14358050427537541
Gnz_k61_2 0 nz_x61 nz_e2 0 0.10101446159528754
Gnz_k61_3 0 nz_x61 nz_e3 0 -0.05987373997508529
Gnz_k61_4 0 nz_x61 nz_e4 0 0.012897574081514051
Gnz_k61_5 0 nz_x61 nz_e5 0 -0.0012851999437638868
Gnz_k61_6 0 nz_x61 nz_e6 0 -0.0009497102179274157
Gnz_k61_7 0 nz_x61 nz_e7 0 -0.0001907771191687171
Gnz_k61_8 0 nz_x61 nz_e8 0 -0.0007671533154615747
Gnz_k61_9 0 nz_x61 nz_e9 0 -0.0008823046541239307
Gnz_k61_10 0 nz_x61 nz_e10 0 -0.2459014894406971
Gnz_k61_11 0 nz_x61 nz_e11 0 0.28702792758157253
Gnz_k61_12 0 nz_x61 nz_e12 0 -0.6161121647588385
Gnz_k61_13 0 nz_x61 nz_e13 0 -0.0013453200859374196
Gnz_k61_14 0 nz_x61 nz_e14 0 0.0020037220587910205
Gnz_k61_15 0 nz_x61 nz_e15 0 -0.0013549129756538565
Cnz_x62 nz_x62 0 1.5871725736917026e-13
Gnz_a62_62 0 nz_x62 nz_x62 0 -0.4303434682550038
Gnz_k62_1 0 nz_x62 nz_e1 0 -0.223855639362107
Gnz_k62_2 0 nz_x62 nz_e2 0 0.07292705075901143
Gnz_k62_3 0 nz_x62 nz_e3 0 -0.06074673263882103
Gnz_k62_4 0 nz_x62 nz_e4 0 -0.035094399557977704
Gnz_k62_5 0 nz_x62 nz_e5 0 0.028706487343140644
Gnz_k62_6 0 nz_x62 nz_e6 0 -0.00169843894696674
Gnz_k62_7 0 nz_x62 nz_e7 0 -0.00018396972395209367
Gnz_k62_8 0 nz_x62 nz_e8 0 -0.00029064085108085395
Gnz_k62_9 0 nz_x62 nz_e9 0 -0.0020458087181957903
Gnz_k62_10 0 nz_x62 nz_e10 0 -0.4096101253032676
Gnz_k62_11 0 nz_x62 nz_e11 0 -0.23076556969110215
Gnz_k62_12 0 nz_x62 nz_e12 0 -0.3439672852530612
Gnz_k62_13 0 nz_x62 nz_e13 0 -3.8194826029043405e-05
Gnz_k62_14 0 nz_x62 nz_e14 0 -0.0005361850673554098
Gnz_k62_15 0 nz_x62 nz_e15 0 -0.0004661131617814731
Cnz_x63 nz_x63 0 1.5871725736917026e-13
Gnz_a63_63 0 nz_x63 nz_x63 0 -0.0686021895257412
Gnz_a63_64 0 nz_x63 nz_x64 0 0.19970950744058633
Gnz_k63_1 0 nz_x63 nz_e1 0 0.006662047484030305
Gnz_k63_2 0 nz_x63 nz_e2 0 0.003042962833353703
Gnz_k63_3 0 nz_x63 nz_e3 0 -0.0027757582116280074
Gnz_k63_4 0 nz_x63 nz_e4 0 0.00138917110758208
Gnz_k63_5 0 nz_x63 nz_e5 0 -0.0014441235061309775
Gnz_k63_6 0 nz_x63 nz_e6 0 6.630771270691693e-05
Gnz_k63_7 0 nz_x63 nz_e7 0 8.341912950892805e-05
Gnz_k63_8 0 nz_x63 nz_e8 0 0.00015950285846290472
Gnz_k63_9 0 nz_x63 nz_e9 0 -0.0003503071884434398
Gnz_k63_10 0 nz_x63 nz_e10 0 -0.02518405168141402
Gnz_k63_11 0 nz_x63 nz_e11 0 -0.007108826217860835
Gnz_k63_12 0 nz_x63 nz_e12 0 -0.01213728875837203
Gnz_k63_13 0 nz_x63 nz_e13 0 8.998033985798164e-05
Gnz_k63_14 0 nz_x63 nz_e14 0 0.00021690215978001384
Gnz_k63_15 0 nz_x63 nz_e15 0 -0.0002437592404461628
Cnz_x64 nz_x64 0 1.5871725736917026e-13
Gnz_a64_63 0 nz_x64 nz_x63 0 -0.19970950744058633
Gnz_a64_64 0 nz_x64 nz_x64 0 -0.0686021895257412
Gnz_k64_1 0 nz_x64 nz_e1 0 0.0066451876616399385
Gnz_k64_2 0 nz_x64 nz_e2 0 0.0034665029910754706
Gnz_k64_3 0 nz_x64 nz_e3 0 -0.00019163067597593677
Gnz_k64_4 0 nz_x64 nz_e4 0 0.007113911914581159
Gnz_k64_5 0 nz_x64 nz_e5 0 -0.0032966264544255094
Gnz_k64_6 0 nz_x64 nz_e6 0 3.451187951331608e-05
Gnz_k64_7 0 nz_x64 nz_e7 0 9.340871304467262e-05
Gnz_k64_8 0 nz_x64 nz_e8 0 0.00017222373707154187
Gnz_k64_9 0 nz_x64 nz_e9 0 2.7840548784091305e-05
Gnz_k64_10 0 nz_x64 nz_e10 0 0.007730008765686018
Gnz_k64_11 0 nz_x64 nz_e11 0 0.03560192049668584
Gnz_k64_12 0 nz_x64 nz_e12 0 -0.005919790516589064
Gnz_k64_13 0 nz_x64 nz_e13 0 -9.395308915871389e-05
Gnz_k64_14 0 nz_x64 nz_e14 0 0.00016497396609780376
Gnz_k64_15 0 nz_x64 nz_e15 0 -0.00010056126060452269
Cnz_x65 nz_x65 0 1.5871725736917026e-13
Gnz_a65_65 0 nz_x65 nz_x65 0 -0.012132536924247928
Gnz_k65_1 0 nz_x65 nz_e1 0 -0.08530676574532962
Gnz_k65_2 0 nz_x65 nz_e2 0 -0.02483293234737009
Gnz_k65_3 0 nz_x65 nz_e3 0 0.0044178851045516485
Gnz_k65_4 0 nz_x65 nz_e4 0 -0.03187004360979989
Gnz_k65_5 0 nz_x65 nz_e5 0 0.028681795034496367
Gnz_k65_6 0 nz_x65 nz_e6 0 -0.0013775788241609701
Gnz_k65_7 0 nz_x65 nz_e7 0 -0.0011093235550448401
Gnz_k65_8 0 nz_x65 nz_e8 0 -0.0013117175659278515
Gnz_k65_9 0 nz_x65 nz_e9 0 0.0020575793294811038
Gnz_k65_10 0 nz_x65 nz_e10 0 0.01941258498827171
Gnz_k65_11 0 nz_x65 nz_e11 0 -0.17004011941767253
Gnz_k65_12 0 nz_x65 nz_e12 0 0.06903731250213983
Gnz_k65_13 0 nz_x65 nz_e13 0 -0.00045851870746507187
Gnz_k65_14 0 nz_x65 nz_e14 0 -0.002476538983253044
Gnz_k65_15 0 nz_x65 nz_e15 0 0.0017809148023910596
Cnz_x66 nz_x66 0 1.5871725736917026e-13
Gnz_a66_66 0 nz_x66 nz_x66 0 -0.19573736862898244
Gnz_k66_1 0 nz_x66 nz_e1 0 -0.10758957866931633
Gnz_k66_2 0 nz_x66 nz_e2 0 -0.0076298386623094615
Gnz_k66_3 0 nz_x66 nz_e3 0 -0.0117289952256732
Gnz_k66_4 0 nz_x66 nz_e4 0 -0.04660739908680405
Gnz_k66_5 0 nz_x66 nz_e5 0 0.033052460068366256
Gnz_k66_6 0 nz_x66 nz_e6 0 -0.0009289517746349904
Gnz_k66_7 0 nz_x66 nz_e7 0 -0.0005674373329293793
Gnz_k66_8 0 nz_x66 nz_e8 0 -0.0012506078271739588
Gnz_k66_9 0 nz_x66 nz_e9 0 -0.00016734346338022213
Gnz_k66_10 0 nz_x66 nz_e10 0 -0.1332964566186507
Gnz_k66_11 0 nz_x66 nz_e11 0 -0.2853598378837375
Gnz_k66_12 0 nz_x66 nz_e12 0 -0.011226407512076377
Gnz_k66_13 0 nz_x66 nz_e13 0 0.00035669502364094996
Gnz_k66_14 0 nz_x66 nz_e14 0 -0.0015452411026197449
Gnz_k66_15 0 nz_x66 nz_e15 0 0.0008618734227131956
Cnz_x67 nz_x67 0 1.5871725736917026e-13
Gnz_a67_67 0 nz_x67 nz_x67 0 -1.0
Gnz_k67_1 0 nz_x67 nz_e1 0 0.11331400068170143
Gnz_k67_2 0 nz_x67 nz_e2 0 -0.1666280167854642
Gnz_k67_3 0 nz_x67 nz_e3 0 0.07129890922672
Gnz_k67_4 0 nz_x67 nz_e4 0 -0.06191676510427578
Gnz_k67_5 0 nz_x67 nz_e5 0 -0.0012389279877354517
Gnz_k67_6 0 nz_x67 nz_e6 0 -0.0022215767944437762
Gnz_k67_7 0 nz_x67 nz_e7 0 0.0019408677995731301
Gnz_k67_8 0 nz_x67 nz_e8 0 0.0047371774893247825
Gnz_k67_9 0 nz_x67 nz_e9 0 -0.0022681817086665675
Gnz_k67_10 0 nz_x67 nz_e10 0 -0.2073869051524553
Gnz_k67_11 0 nz_x67 nz_e11 0 -0.15382640910822382
Gnz_k67_12 0 nz_x67 nz_e12 0 0.8146032829057394
Gnz_k67_13 0 nz_x67 nz_e13 0 0.000336393059333141
Gnz_k67_14 0 nz_x67 nz_e14 0 -0.005005769458018273
Gnz_k67_15 0 nz_x67 nz_e15 0 0.0028955022765315185
Cnz_x68 nz_x68 0 1.5871725736917026e-13
Gnz_a68_68 0 nz_x68 nz_x68 0 -0.4303434682550038
Gnz_k68_1 0 nz_x68 nz_e1 0 0.12215987746181954
Gnz_k68_2 0 nz_x68 nz_e2 0 -0.10063159154858868
Gnz_k68_3 0 nz_x68 nz_e3 0 0.07425484458930766
Gnz_k68_4 0 nz_x68 nz_e4 0 -0.10769818301168996
Gnz_k68_5 0 nz_x68 nz_e5 0 0.04418947638669504
Gnz_k68_6 0 nz_x68 nz_e6 0 -0.0006654685016539302
Gnz_k68_7 0 nz_x68 nz_e7 0 8.059256014626114e-05
Gnz_k68_8 0 nz_x68 nz_e8 0 0.001452190440365879
Gnz_k68_9 0 nz_x68 nz_e9 0 -0.00048759992499743267
Gnz_k68_10 0 nz_x68 nz_e10 0 -0.22640043945399008
Gnz_k68_11 0 nz_x68 nz_e11 0 -0.252310556501551
Gnz_k68_12 0 nz_x68 nz_e12 0 0.32106548481188846
Gnz_k68_13 0 nz_x68 nz_e13 0 2.7504511327417158e-05
Gnz_k68_14 0 nz_x68 nz_e14 0 -0.0019152186489682142
Gnz_k68_15 0 nz_x68 nz_e15 0 0.0008037073399191315
Cnz_x69 nz_x69 0 1.5871725736917026e-13
Gnz_a69_69 0 nz_x69 nz_x69 0 -0.0686021895257412
Gnz_a69_70 0 nz_x69 nz_x70 0 0.19970950744058633
Gnz_k69_1 0 nz_x69 nz_e1 0 0.011696451167427586
Gnz_k69_2 0 nz_x69 nz_e2 0 -0.0022624238649300472
Gnz_k69_3 0 nz_x69 nz_e3 0 0.0009319035641126351
Gnz_k69_4 0 nz_x69 nz_e4 0 -0.0035382054980762283
Gnz_k69_5 0 nz_x69 nz_e5 0 0.00040744050882053005
Gnz_k69_6 0 nz_x69 nz_e6 0 0.000108570268606942
Gnz_k69_7 0 nz_x69 nz_e7 0 2.2985221542680794e-05
Gnz_k69_8 0 nz_x69 nz_e8 0 7.339206855350097e-05
Gnz_k69_9 0 nz_x69 nz_e9 0 -9.844922734418889e-05
Gnz_k69_10 0 nz_x69 nz_e10 0 -0.01884101760087883
Gnz_k69_11 0 nz_x69 nz_e11 0 -0.014585955679390087
Gnz_k69_12 0 nz_x69 nz_e12 0 0.014847716239465241
Gnz_k69_13 0 nz_x69 nz_e13 0 1.818757936259176e-05
Gnz_k69_14 0 nz_x69 nz_e14 0 8.744099093633784e-05
Gnz_k69_15 0 nz_x69 nz_e15 0 -0.0001846540976117812
Cnz_x70 nz_x70 0 1.5871725736917026e-13
Gnz_a70_69 0 nz_x70 nz_x69 0 -0.19970950744058633
Gnz_a70_70 0 nz_x70 nz_x70 0 -0.0686021895257412
Gnz_k70_1 0 nz_x70 nz_e1 0 0.001023921806795721
Gnz_k70_2 0 nz_x70 nz_e2 0 -0.005504857489700538
Gnz_k70_3 0 nz_x70 nz_e3 0 -0.0026050719275482266
Gnz_k70_4 0 nz_x70 nz_e4 0 0.010644384726658076
Gnz_k70_5 0 nz_x70 nz_e5 0 -0.006015157108303425
Gnz_k70_6 0 nz_x70 nz_e6 0 3.598257415951486e-05
Gnz_k70_7 0 nz_x70 nz_e7 0 0.00018163738728859189
Gnz_k70_8 0 nz_x70 nz_e8 0 0.0005355058635181358
Gnz_k70_9 0 nz_x70 nz_e9 0 -2.9112732899132606e-05
Gnz_k70_10 0 nz_x70 nz_e10 0 0.008473483369272764
Gnz_k70_11 0 nz_x70 nz_e11 0 0.021963699900118448
Gnz_k70_12 0 nz_x70 nz_e12 0 0.020344608786592992
Gnz_k70_13 0 nz_x70 nz_e13 0 -7.811096205171508e-05
Gnz_k70_14 0 nz_x70 nz_e14 0 0.00018704513541904105
Gnz_k70_15 0 nz_x70 nz_e15 0 -7.755620681692086e-05
Cnz_x71 nz_x71 0 1.5871725736917026e-13
Gnz_a71_71 0 nz_x71 nz_x71 0 -0.012132536924247928
Gnz_k71_1 0 nz_x71 nz_e1 0 -0.016503668002475613
Gnz_k71_2 0 nz_x71 nz_e2 0 0.008660336408322394
Gnz_k71_3 0 nz_x71 nz_e3 0 0.018164135844755045
Gnz_k71_4 0 nz_x71 nz_e4 0 -0.06047730501844179
Gnz_k71_5 0 nz_x71 nz_e5 0 0.057363071049952315
Gnz_k71_6 0 nz_x71 nz_e6 0 -0.0019242776028384674
Gnz_k71_7 0 nz_x71 nz_e7 0 -0.0017035651613035842
Gnz_k71_8 0 nz_x71 nz_e8 0 -0.0029036439908845125
Gnz_k71_9 0 nz_x71 nz_e9 0 0.0011061796385786777
Gnz_k71_10 0 nz_x71 nz_e10 0 0.001980923788508356
Gnz_k71_11 0 nz_x71 nz_e11 0 -0.09046822300094672
Gnz_k71_12 0 nz_x71 nz_e12 0 -0.15461744920987558
Gnz_k71_13 0 nz_x71 nz_e13 0 0.0003876395182588395
Gnz_k71_14 0 nz_x71 nz_e14 0 -0.0021426739934111874
Gnz_k71_15 0 nz_x71 nz_e15 0 0.002119093017334668
Cnz_x72 nz_x72 0 1.5871725736917026e-13
Gnz_a72_72 0 nz_x72 nz_x72 0 -0.19573736862898244
Gnz_k72_1 0 nz_x72 nz_e1 0 0.0874242077621112
Gnz_k72_2 0 nz_x72 nz_e2 0 -0.019434009872448643
Gnz_k72_3 0 nz_x72 nz_e3 0 0.07947872817174358
Gnz_k72_4 0 nz_x72 nz_e4 0 -0.1782348618940767
Gnz_k72_5 0 nz_x72 nz_e5 0 0.10151295367279456
Gnz_k72_6 0 nz_x72 nz_e6 0 -0.0005244974015240648
Gnz_k72_7 0 nz_x72 nz_e7 0 -0.0021069358106938036
Gnz_k72_8 0 nz_x72 nz_e8 0 -0.003489824235417458
Gnz_k72_9 0 nz_x72 nz_e9 0 0.0007926553717792239
Gnz_k72_10 0 nz_x72 nz_e10 0 -0.2241469012220621
Gnz_k72_11 0 nz_x72 nz_e11 0 -0.37684420264914187
Gnz_k72_12 0 nz_x72 nz_e12 0 -0.023080117833409887
Gnz_k72_13 0 nz_x72 nz_e13 0 0.0004410299623038825
Gnz_k72_14 0 nz_x72 nz_e14 0 -0.002251024408543366
Gnz_k72_15 0 nz_x72 nz_e15 0 0.0007691072286457301
Cnz_x73 nz_x73 0 1.5871725736917026e-13
Gnz_a73_73 0 nz_x73 nz_x73 0 -1.0
Gnz_k73_1 0 nz_x73 nz_e1 0 0.002336422927074383
Gnz_k73_2 0 nz_x73 nz_e2 0 -0.0010472894660174155
Gnz_k73_3 0 nz_x73 nz_e3 0 4.4641355037845565e-06
Gnz_k73_4 0 nz_x73 nz_e4 0 4.289606624362678e-05
Gnz_k73_5 0 nz_x73 nz_e5 0 -0.0009934445753373223
Gnz_k73_6 0 nz_x73 nz_e6 0 0.14669909840479967
Gnz_k73_7 0 nz_x73 nz_e7 0 -0.22385375710833594
Gnz_k73_8 0 nz_x73 nz_e8 0 0.1380268243965087
Gnz_k73_9 0 nz_x73 nz_e9 0 -0.24541745646901716
Gnz_k73_10 0 nz_x73 nz_e10 0 0.004573954440152603
Gnz_k73_11 0 nz_x73 nz_e11 0 -0.004021121289854519
Gnz_k73_12 0 nz_x73 nz_e12 0 -0.003262134953002466
Gnz_k73_13 0 nz_x73 nz_e13 0 -0.5677963358982564
Gnz_k73_14 0 nz_x73 nz_e14 0 -0.30133281588001015
Gnz_k73_15 0 nz_x73 nz_e15 0 -0.12285882552928348
Cnz_x74 nz_x74 0 1.5871725736917026e-13
Gnz_a74_74 0 nz_x74 nz_x74 0 -0.4303434682550038
Gnz_k74_1 0 nz_x74 nz_e1 0 0.0009254485745298854
Gnz_k74_2 0 nz_x74 nz_e2 0 -0.00038926862798042907
Gnz_k74_3 0 nz_x74 nz_e3 0 0.00027487107979578526
Gnz_k74_4 0 nz_x74 nz_e4 0 -0.00030601544422113213
Gnz_k74_5 0 nz_x74 nz_e5 0 -9.541495659953128e-05
Gnz_k74_6 0 nz_x74 nz_e6 0 0.07578652944495252
Gnz_k74_7 0 nz_x74 nz_e7 0 -0.10867420447429749
Gnz_k74_8 0 nz_x74 nz_e8 0 0.07644604770612587
Gnz_k74_9 0 nz_x74 nz_e9 0 -0.12288379066190533
Gnz_k74_10 0 nz_x74 nz_e10 0 0.0016520771240513782
Gnz_k74_11 0 nz_x74 nz_e11 0 -0.0019180618883158636
Gnz_k74_12 0 nz_x74 nz_e12 0 -0.0016730359758539287
Gnz_k74_13 0 nz_x74 nz_e13 0 -0.3528570491503316
Gnz_k74_14 0 nz_x74 nz_e14 0 -0.15454274982056473
Gnz_k74_15 0 nz_x74 nz_e15 0 -0.06145303632597609
Cnz_x75 nz_x75 0 1.5871725736917026e-13
Gnz_a75_75 0 nz_x75 nz_x75 0 -0.0686021895257412
Gnz_a75_76 0 nz_x75 nz_x76 0 0.19970950744058633
Gnz_k75_1 0 nz_x75 nz_e1 0 8.300977064681334e-05
Gnz_k75_2 0 nz_x75 nz_e2 0 -0.0001766553085246929
Gnz_k75_3 0 nz_x75 nz_e3 0 5.873744600530707e-06
Gnz_k75_4 0 nz_x75 nz_e4 0 -0.00017183542810295392
Gnz_k75_5 0 nz_x75 nz_e5 0 4.346869496934484e-05
Gnz_k75_6 0 nz_x75 nz_e6 0 0.01073730449682372
Gnz_k75_7 0 nz_x75 nz_e7 0 -0.0013013687151865894
Gnz_k75_8 0 nz_x75 nz_e8 0 0.011705795324631323
Gnz_k75_9 0 nz_x75 nz_e9 0 -0.004085415394379374
Gnz_k75_10 0 nz_x75 nz_e10 0 0.00038302744908098993
Gnz_k75_11 0 nz_x75 nz_e11 0 -0.0002433047800039409
Gnz_k75_12 0 nz_x75 nz_e12 0 -0.0001756869364031389
Gnz_k75_13 0 nz_x75 nz_e13 0 -0.043298864456404296
Gnz_k75_14 0 nz_x75 nz_e14 0 -0.02498879957760947
Gnz_k75_15 0 nz_x75 nz_e15 0 -0.010975729672524576
Cnz_x76 nz_x76 0 1.5871725736917026e-13
Gnz_a76_75 0 nz_x76 nz_x75 0 -0.19970950744058633
Gnz_a76_76 0 nz_x76 nz_x76 0 -0.0686021895257412
Gnz_k76_1 0 nz_x76 nz_e1 0 -0.00021704921312514625
Gnz_k76_2 0 nz_x76 nz_e2 0 8.987334727533606e-05
Gnz_k76_3 0 nz_x76 nz_e3 0 -0.00035045053623786496
Gnz_k76_4 0 nz_x76 nz_e4 0 -0.00022064076982527362
Gnz_k76_5 0 nz_x76 nz_e5 0 8.167859883357875e-05
Gnz_k76_6 0 nz_x76 nz_e6 0 -0.02016004126906075
Gnz_k76_7 0 nz_x76 nz_e7 0 0.036601667007698735
Gnz_k76_8 0 nz_x76 nz_e8 0 -0.022044065724933126
Gnz_k76_9 0 nz_x76 nz_e9 0 0.0412375235484876
Gnz_k76_10 0 nz_x76 nz_e10 0 -3.4695243558084615e-05
Gnz_k76_11 0 nz_x76 nz_e11 0 0.0005128880384547295
Gnz_k76_12 0 nz_x76 nz_e12 0 0.0003426521434288408
Gnz_k76_13 0 nz_x76 nz_e13 0 0.1294971194406716
Gnz_k76_14 0 nz_x76 nz_e14 0 0.04191588166277168
Gnz_k76_15 0 nz_x76 nz_e15 0 0.014179702787616127
Cnz_x77 nz_x77 0 1.5871725736917026e-13
Gnz_a77_77 0 nz_x77 nz_x77 0 -0.012132536924247928
Gnz_k77_1 0 nz_x77 nz_e1 0 0.0007816844051946423
Gnz_k77_2 0 nz_x77 nz_e2 0 8.469315503740694e-05
Gnz_k77_3 0 nz_x77 nz_e3 0 0.0004939544577583968
Gnz_k77_4 0 nz_x77 nz_e4 0 0.00012542424404298733
Gnz_k77_5 0 nz_x77 nz_e5 0 -0.000537404441201971
Gnz_k77_6 0 nz_x77 nz_e6 0 0.029551678503333324
Gnz_k77_7 0 nz_x77 nz_e7 0 -0.04109164672904736
Gnz_k77_8 0 nz_x77 nz_e8 0 0.03402548306806591
Gnz_k77_9 0 nz_x77 nz_e9 0 -0.04266427079376489
Gnz_k77_10 0 nz_x77 nz_e10 0 -0.0016678610367083316
Gnz_k77_11 0 nz_x77 nz_e11 0 -0.0015189655606358467
Gnz_k77_12 0 nz_x77 nz_e12 0 -0.0002507836720201338
Gnz_k77_13 0 nz_x77 nz_e13 0 -0.16116418730508766
Gnz_k77_14 0 nz_x77 nz_e14 0 -0.05593353783738207
Gnz_k77_15 0 nz_x77 nz_e15 0 -0.01875797353299404
Cnz_x78 nz_x78 0 1.5871725736917026e-13
Gnz_a78_78 0 nz_x78 nz_x78 0 -0.19573736862898244
Gnz_k78_1 0 nz_x78 nz_e1 0 0.00029381427890858795
Gnz_k78_2 0 nz_x78 nz_e2 0 -9.370338104169229e-05
Gnz_k78_3 0 nz_x78 nz_e3 0 0.00019004915050107235
Gnz_k78_4 0 nz_x78 nz_e4 0 -2.234113102304881e-05
Gnz_k78_5 0 nz_x78 nz_e5 0 -5.663982018441342e-05
Gnz_k78_6 0 nz_x78 nz_e6 0 0.02500269737541603
Gnz_k78_7 0 nz_x78 nz_e7 0 -0.03897112550667509
Gnz_k78_8 0 nz_x78 nz_e8 0 0.02607600983252041
Gnz_k78_9 0 nz_x78 nz_e9 0 -0.043666702547403353
Gnz_k78_10 0 nz_x78 nz_e10 0 0.00035153547311912725
Gnz_k78_11 0 nz_x78 nz_e11 0 -0.0006243183546187341
Gnz_k78_12 0 nz_x78 nz_e12 0 -0.000514963091610172
Gnz_k78_13 0 nz_x78 nz_e13 0 -0.1328654708325683
Gnz_k78_14 0 nz_x78 nz_e14 0 -0.04974248037884859
Gnz_k78_15 0 nz_x78 nz_e15 0 -0.018901822872292497
Cnz_x79 nz_x79 0 1.5871725736917026e-13
Gnz_a79_79 0 nz_x79 nz_x79 0 -1.0
Gnz_k79_1 0 nz_x79 nz_e1 0 0.0022014030606979816
Gnz_k79_2 0 nz_x79 nz_e2 0 0.0027800066830381913
Gnz_k79_3 0 nz_x79 nz_e3 0 -0.0019653350001756728
Gnz_k79_4 0 nz_x79 nz_e4 0 -0.003209730478696963
Gnz_k79_5 0 nz_x79 nz_e5 0 -0.0030204170836680313
Gnz_k79_6 0 nz_x79 nz_e6 0 -0.162495968972888
Gnz_k79_7 0 nz_x79 nz_e7 0 0.1984560555361079
Gnz_k79_8 0 nz_x79 nz_e8 0 -0.14464241081435578
Gnz_k79_9 0 nz_x79 nz_e9 0 0.20274695028748277
Gnz_k79_10 0 nz_x79 nz_e10 0 -0.009987926876262196
Gnz_k79_11 0 nz_x79 nz_e11 0 0.0046267288032923
Gnz_k79_12 0 nz_x79 nz_e12 0 0.0038965142744902996
Gnz_k79_13 0 nz_x79 nz_e13 0 -0.42170762659819006
Gnz_k79_14 0 nz_x79 nz_e14 0 -0.4072309098348965
Gnz_k79_15 0 nz_x79 nz_e15 0 0.15662387102871542
Cnz_x80 nz_x80 0 1.5871725736917026e-13
Gnz_a80_80 0 nz_x80 nz_x80 0 -0.4303434682550038
Gnz_k80_1 0 nz_x80 nz_e1 0 0.003303976089275441
Gnz_k80_2 0 nz_x80 nz_e2 0 0.001281640508031273
Gnz_k80_3 0 nz_x80 nz_e3 0 -0.0008390103258606995
Gnz_k80_4 0 nz_x80 nz_e4 0 -0.0004918242059021679
Gnz_k80_5 0 nz_x80 nz_e5 0 -0.0025672951240146586
Gnz_k80_6 0 nz_x80 nz_e6 0 -0.09584770820744586
Gnz_k80_7 0 nz_x80 nz_e7 0 0.11465415813764274
Gnz_k80_8 0 nz_x80 nz_e8 0 -0.08399967261532161
Gnz_k80_9 0 nz_x80 nz_e9 0 0.11977903257359232
Gnz_k80_10 0 nz_x80 nz_e10 0 -0.004731068836601965
Gnz_k80_11 0 nz_x80 nz_e11 0 0.0032143061725269776
Gnz_k80_12 0 nz_x80 nz_e12 0 0.0019284284516849484
Gnz_k80_13 0 nz_x80 nz_e13 0 -0.22703607604827908
Gnz_k80_14 0 nz_x80 nz_e14 0 -0.26329699309136484
Gnz_k80_15 0 nz_x80 nz_e15 0 0.09103965845344157
Cnz_x81 nz_x81 0 1.5871725736917026e-13
Gnz_a81_81 0 nz_x81 nz_x81 0 -0.0686021895257412
Gnz_a81_82 0 nz_x81 nz_x82 0 0.19970950744058633
Gnz_k81_1 0 nz_x81 nz_e1 0 0.00040516461442363687
Gnz_k81_2 0 nz_x81 nz_e2 0 9.31736782369643e-05
Gnz_k81_3 0 nz_x81 nz_e3 0 5.150381149357258e-05
Gnz_k81_4 0 nz_x81 nz_e4 0 -5.556066522378894e-05
Gnz_k81_5 0 nz_x81 nz_e5 0 -0.0003052992337679373
Gnz_k81_6 0 nz_x81 nz_e6 0 -0.022455475404734786
Gnz_k81_7 0 nz_x81 nz_e7 0 0.020338386403321376
Gnz_k81_8 0 nz_x81 nz_e8 0 -0.019753232836354186
Gnz_k81_9 0 nz_x81 nz_e9 0 0.021537028902305785
Gnz_k81_10 0 nz_x81 nz_e10 0 -0.0006466663044218894
Gnz_k81_11 0 nz_x81 nz_e11 0 0.0006556597557030434
Gnz_k81_12 0 nz_x81 nz_e12 0 0.0005995909212135407
Gnz_k81_13 0 nz_x81 nz_e13 0 -0.03670036220006742
Gnz_k81_14 0 nz_x81 nz_e14 0 -0.05250731902397023
Gnz_k81_15 0 nz_x81 nz_e15 0 0.02036626261845541
Cnz_x82 nz_x82 0 1.5871725736917026e-13
Gnz_a82_81 0 nz_x82 nz_x81 0 -0.19970950744058633
Gnz_a82_82 0 nz_x82 nz_x82 0 -0.0686021895257412
Gnz_k82_1 0 nz_x82 nz_e1 0 -0.0014185879698746524
Gnz_k82_2 0 nz_x82 nz_e2 0 -0.0003958597617851521
Gnz_k82_3 0 nz_x82 nz_e3 0 0.0005260564621975987
Gnz_k82_4 0 nz_x82 nz_e4 0 -5.745873063194913e-05
Gnz_k82_5 0 nz_x82 nz_e5 0 0.0006959008824203429
Gnz_k82_6 0 nz_x82 nz_e6 0 0.018059399556872677
Gnz_k82_7 0 nz_x82 nz_e7 0 -0.030718048922429977
Gnz_k82_8 0 nz_x82 nz_e8 0 0.013078008158044689
Gnz_k82_9 0 nz_x82 nz_e9 0 -0.0297148512893848
Gnz_k82_10 0 nz_x82 nz_e10 0 0.0010643699633218844
Gnz_k82_11 0 nz_x82 nz_e11 0 -0.000593994364613305
Gnz_k82_12 0 nz_x82 nz_e12 0 0.0005677738964296176
Gnz_k82_13 0 nz_x82 nz_e13 0 0.054798289761082385
Gnz_k82_14 0 nz_x82 nz_e14 0 0.07208993647589523
Gnz_k82_15 0 nz_x82 nz_e15 0 -0.0174024019725063
Cnz_x83 nz_x83 0 1.5871725736917026e-13
Gnz_a83_83 0 nz_x83 nz_x83 0 -0.012132536924247928
Gnz_k83_1 0 nz_x83 nz_e1 0 0.002620984310146889
Gnz_k83_2 0 nz_x83 nz_e2 0 0.0007657498604740586
Gnz_k83_3 0 nz_x83 nz_e3 0 -0.0008923766642852191
Gnz_k83_4 0 nz_x83 nz_e4 0 0.00010654936036121507
Gnz_k83_5 0 nz_x83 nz_e5 0 -0.001511869428545553
Gnz_k83_6 0 nz_x83 nz_e6 0 -0.02368062577114748
Gnz_k83_7 0 nz_x83 nz_e7 0 0.05175910383972274
Gnz_k83_8 0 nz_x83 nz_e8 0 -0.013560549349849982
Gnz_k83_9 0 nz_x83 nz_e9 0 0.05184874593830823
Gnz_k83_10 0 nz_x83 nz_e10 0 -0.002105131830805941
Gnz_k83_11 0 nz_x83 nz_e11 0 0.00021413017068781367
Gnz_k83_12 0 nz_x83 nz_e12 0 -0.0008879650477618213
Gnz_k83_13 0 nz_x83 nz_e13 0 -0.09155132306781852
Gnz_k83_14 0 nz_x83 nz_e14 0 -0.10906605024176763
Gnz_k83_15 0 nz_x83 nz_e15 0 0.019984410799056624
Cnz_x84 nz_x84 0 1.5871725736917026e-13
Gnz_a84_84 0 nz_x84 nz_x84 0 -0.19573736862898244
Gnz_k84_1 0 nz_x84 nz_e1 0 0.001590287457065294
Gnz_k84_2 0 nz_x84 nz_e2 0 0.000490903853220792
Gnz_k84_3 0 nz_x84 nz_e3 0 -0.0004281381005259131
Gnz_k84_4 0 nz_x84 nz_e4 0 -2.8614467016648133e-05
Gnz_k84_5 0 nz_x84 nz_e5 0 -0.001029596752260228
Gnz_k84_6 0 nz_x84 nz_e6 0 -0.03098954451892278
Gnz_k84_7 0 nz_x84 nz_e7 0 0.04102160443255596
Gnz_k84_8 0 nz_x84 nz_e8 0 -0.025575723027583118
Gnz_k84_9 0 nz_x84 nz_e9 0 0.04184484427892216
Gnz_k84_10 0 nz_x84 nz_e10 0 -0.001627080009081345
Gnz_k84_11 0 nz_x84 nz_e11 0 0.0011311466288778016
Gnz_k84_12 0 nz_x84 nz_e12 0 0.00019914459222076028
Gnz_k84_13 0 nz_x84 nz_e13 0 -0.07769154075263955
Gnz_k84_14 0 nz_x84 nz_e14 0 -0.0966130824125879
Gnz_k84_15 0 nz_x84 nz_e15 0 0.029364230141952167
Cnz_x85 nz_x85 0 1.5871725736917026e-13
Gnz_a85_85 0 nz_x85 nz_x85 0 -1.0
Gnz_k85_1 0 nz_x85 nz_e1 0 -0.003180355048497051
Gnz_k85_2 0 nz_x85 nz_e2 0 -0.0022956362140499173
Gnz_k85_3 0 nz_x85 nz_e3 0 0.0018713515438002276
Gnz_k85_4 0 nz_x85 nz_e4 0 0.0009579329984719487
Gnz_k85_5 0 nz_x85 nz_e5 0 0.00294173319736152
Gnz_k85_6 0 nz_x85 nz_e6 0 -0.3886808000810353
Gnz_k85_7 0 nz_x85 nz_e7 0 0.2452495899632229
Gnz_k85_8 0 nz_x85 nz_e8 0 0.10283390146530186
Gnz_k85_9 0 nz_x85 nz_e9 0 -0.08705560900016783
Gnz_k85_10 0 nz_x85 nz_e10 0 0.009447815504578613
Gnz_k85_11 0 nz_x85 nz_e11 0 -0.002568287463109188
Gnz_k85_12 0 nz_x85 nz_e12 0 -0.0033848794739328456
Gnz_k85_13 0 nz_x85 nz_e13 0 -0.12744654980380088
Gnz_k85_14 0 nz_x85 nz_e14 0 0.08897310417953509
Gnz_k85_15 0 nz_x85 nz_e15 0 -0.4446433510181129
Cnz_x86 nz_x86 0 1.5871725736917026e-13
Gnz_a86_86 0 nz_x86 nz_x86 0 -0.4303434682550038
Gnz_k86_1 0 nz_x86 nz_e1 0 -0.0012543196526828059
Gnz_k86_2 0 nz_x86 nz_e2 0 -0.0014983114696810954
Gnz_k86_3 0 nz_x86 nz_e3 0 0.001047588452984391
Gnz_k86_4 0 nz_x86 nz_e4 0 -0.0007525407305204274
Gnz_k86_5 0 nz_x86 nz_e5 0 0.0019599946365554703
Gnz_k86_6 0 nz_x86 nz_e6 0 -0.1809906003223988
Gnz_k86_7 0 nz_x86 nz_e7 0 0.11643507959295078
Gnz_k86_8 0 nz_x86 nz_e8 0 0.04677838422749516
Gnz_k86_9 0 nz_x86 nz_e9 0 -0.04306713149612344
Gnz_k86_10 0 nz_x86 nz_e10 0 0.004265409033392122
Gnz_k86_11 0 nz_x86 nz_e11 0 -0.0016622102189964908
Gnz_k86_12 0 nz_x86 nz_e12 0 -0.0017688551837398954
Gnz_k86_13 0 nz_x86 nz_e13 0 -0.05911695786363831
Gnz_k86_14 0 nz_x86 nz_e14 0 0.04197423113669772
Gnz_k86_15 0 nz_x86 nz_e15 0 -0.27714306274260886
Cnz_x87 nz_x87 0 1.5871725736917026e-13
Gnz_a87_87 0 nz_x87 nz_x87 0 -0.0686021895257412
Gnz_a87_88 0 nz_x87 nz_x88 0 0.19970950744058633
Gnz_k87_1 0 nz_x87 nz_e1 0 -0.0003470911008188314
Gnz_k87_2 0 nz_x87 nz_e2 0 -0.0003467706603389994
Gnz_k87_3 0 nz_x87 nz_e3 0 0.0002481369738099319
Gnz_k87_4 0 nz_x87 nz_e4 0 -0.000350216410992517
Gnz_k87_5 0 nz_x87 nz_e5 0 0.0005957622357034494
Gnz_k87_6 0 nz_x87 nz_e6 0 -0.010367963797632815
Gnz_k87_7 0 nz_x87 nz_e7 0 0.021416296792583004
Gnz_k87_8 0 nz_x87 nz_e8 0 0.010704471695997964
Gnz_k87_9 0 nz_x87 nz_e9 0 -0.00683487969406792
Gnz_k87_10 0 nz_x87 nz_e10 0 0.0008350643474502646
Gnz_k87_11 0 nz_x87 nz_e11 0 -0.0005927090159781302
Gnz_k87_12 0 nz_x87 nz_e12 0 -0.00038178072433032014
Gnz_k87_13 0 nz_x87 nz_e13 0 -0.010692806372735446
Gnz_k87_14 0 nz_x87 nz_e14 0 0.009672539140298458
Gnz_k87_15 0 nz_x87 nz_e15 0 -0.03448156267721279
Cnz_x88 nz_x88 0 1.5871725736917026e-13
Gnz_a88_87 0 nz_x88 nz_x87 0 -0.19970950744058633
Gnz_a88_88 0 nz_x88 nz_x88 0 -0.0686021895257412
Gnz_k88_1 0 nz_x88 nz_e1 0 7.589681327595932e-05
Gnz_k88_2 0 nz_x88 nz_e2 0 0.00037630976647264806
Gnz_k88_3 0 nz_x88 nz_e3 0 -0.0001022597131756967
Gnz_k88_4 0 nz_x88 nz_e4 0 0.00041359588883229027
Gnz_k88_5 0 nz_x88 nz_e5 0 -0.00042830342540433887
Gnz_k88_6 0 nz_x88 nz_e6 0 0.059569666393248295
Gnz_k88_7 0 nz_x88 nz_e7 0 -0.02758657444833199
Gnz_k88_8 0 nz_x88 nz_e8 0 -0.00842570611610995
Gnz_k88_9 0 nz_x88 nz_e9 0 0.011485204338680754
Gnz_k88_10 0 nz_x88 nz_e10 0 -0.0010012618667572992
Gnz_k88_11 0 nz_x88 nz_e11 0 0.0004869141454265025
Gnz_k88_12 0 nz_x88 nz_e12 0 0.00011779153125493335
Gnz_k88_13 0 nz_x88 nz_e13 0 0.014207449378469456
Gnz_k88_14 0 nz_x88 nz_e14 0 -0.007395437481263875
Gnz_k88_15 0 nz_x88 nz_e15 0 0.10824537317932122
Cnz_x89 nz_x89 0 1.5871725736917026e-13
Gnz_a89_89 0 nz_x89 nz_x89 0 -0.012132536924247928
Gnz_k89_1 0 nz_x89 nz_e1 0 0.00013171360287997168
Gnz_k89_2 0 nz_x89 nz_e2 0 -0.0003051180070576548
Gnz_k89_3 0 nz_x89 nz_e3 0 8.152431670733172e-05
Gnz_k89_4 0 nz_x89 nz_e4 0 -3.459146606864126e-05
Gnz_k89_5 0 nz_x89 nz_e5 0 0.00024788030480538955
Gnz_k89_6 0 nz_x89 nz_e6 0 -0.07722713179753882
Gnz_k89_7 0 nz_x89 nz_e7 0 0.04391172269607658
Gnz_k89_8 0 nz_x89 nz_e8 0 0.0026204184157159905
Gnz_k89_9 0 nz_x89 nz_e9 0 -0.018383364856177763
Gnz_k89_10 0 nz_x89 nz_e10 0 0.0017898377668845052
Gnz_k89_11 0 nz_x89 nz_e11 0 0.00012476694014207409
Gnz_k89_12 0 nz_x89 nz_e12 0 -4.7610893618619545e-05
Gnz_k89_13 0 nz_x89 nz_e13 0 -0.018907839987832846
Gnz_k89_14 0 nz_x89 nz_e14 0 0.004481016864463662
Gnz_k89_15 0 nz_x89 nz_e15 0 -0.1328067412048585
Cnz_x90 nz_x90 0 1.5871725736917026e-13
Gnz_a90_90 0 nz_x90 nz_x90 0 -0.19573736862898244
Gnz_k90_1 0 nz_x90 nz_e1 0 -0.00024702679504168945
Gnz_k90_2 0 nz_x90 nz_e2 0 -0.0004663500154148735
Gnz_k90_3 0 nz_x90 nz_e3 0 0.00029032470523808045
Gnz_k90_4 0 nz_x90 nz_e4 0 -0.0003323301988522827
Gnz_k90_5 0 nz_x90 nz_e5 0 0.0005991750071963243
Gnz_k90_6 0 nz_x90 nz_e6 0 -0.06443910501818643
Gnz_k90_7 0 nz_x90 nz_e7 0 0.036453152502227526
Gnz_k90_8 0 nz_x90 nz_e8 0 0.012842431775432794
Gnz_k90_9 0 nz_x90 nz_e9 0 -0.014093466256689731
Gnz_k90_10 0 nz_x90 nz_e10 0 0.001353547095278214
Gnz_k90_11 0 nz_x90 nz_e11 0 -0.0005218591176878731
Gnz_k90_12 0 nz_x90 nz_e12 0 -0.0004748464920086759
Gnz_k90_13 0 nz_x90 nz_e13 0 -0.01835698809591323
Gnz_k90_14 0 nz_x90 nz_e14 0 0.011831902653335741
Gnz_k90_15 0 nz_x90 nz_e15 0 -0.1085433216792979
Gnz_c1_1 0 s1 nz_x1 0 -0.4712538129404236
Gnz_c1_2 0 s1 nz_x2 0 0.5524759819001714
Gnz_c1_3 0 s1 nz_x3 0 0.04434764123778412
Gnz_c1_4 0 s1 nz_x4 0 -0.003149355949471842
Gnz_c1_5 0 s1 nz_x5 0 0.08499375952185192
Gnz_c1_6 0 s1 nz_x6 0 -0.10071410933632013
Gnz_c1_7 0 s1 nz_x7 0 0.007676015286742862
Gnz_c1_8 0 s1 nz_x8 0 -0.002178205848848921
Gnz_c1_9 0 s1 nz_x9 0 0.003714596888778351
Gnz_c1_10 0 s1 nz_x10 0 -0.0014026407879832148
Gnz_c1_11 0 s1 nz_x11 0 0.03531975711046788
Gnz_c1_12 0 s1 nz_x12 0 0.037658608303947544
Gnz_c1_13 0 s1 nz_x13 0 -0.02414844859493652
Gnz_c1_14 0 s1 nz_x14 0 -0.019590292994106532
Gnz_c1_15 0 s1 nz_x15 0 0.0019365037966317604
Gnz_c1_16 0 s1 nz_x16 0 0.0017903645494824023
Gnz_c1_17 0 s1 nz_x17 0 -0.0355988491162239
Gnz_c1_18 0 s1 nz_x18 0 -0.031213688450230485
Gnz_c1_19 0 s1 nz_x19 0 0.005613919206734155
Gnz_c1_20 0 s1 nz_x20 0 0.09045001847211805
Gnz_c1_21 0 s1 nz_x21 0 0.008084447450785504
Gnz_c1_22 0 s1 nz_x22 0 -0.003980465649019766
Gnz_c1_23 0 s1 nz_x23 0 0.08642670519207903
Gnz_c1_24 0 s1 nz_x24 0 0.05736630862616649
Gnz_c1_25 0 s1 nz_x25 0 -0.11186539451158235
Gnz_c1_26 0 s1 nz_x26 0 -0.033868482284967985
Gnz_c1_27 0 s1 nz_x27 0 -0.004091258142407585
Gnz_c1_28 0 s1 nz_x28 0 0.0013618012166647067
Gnz_c1_29 0 s1 nz_x29 0 -0.03638321004939827
Gnz_c1_30 0 s1 nz_x30 0 -0.05751303814366596
Gnz_c1_31 0 s1 nz_x31 0 0.0003420135425056406
Gnz_c1_32 0 s1 nz_x32 0 -0.002245900457666038
Gnz_c1_33 0 s1 nz_x33 0 0.0018975307335322973
Gnz_c1_34 0 s1 nz_x34 0 -0.002274295245536942
Gnz_c1_35 0 s1 nz_x35 0 -0.07670849020919648
Gnz_c1_36 0 s1 nz_x36 0 0.0034280471357074835
Gnz_c1_37 0 s1 nz_x37 0 -0.004508959230433056
Gnz_c1_38 0 s1 nz_x38 0 0.01062441756262036
Gnz_c1_39 0 s1 nz_x39 0 -0.0017576024539075821
Gnz_c1_40 0 s1 nz_x40 0 0.002285823943588315
Gnz_c1_41 0 s1 nz_x41 0 0.07950468466936242
Gnz_c1_42 0 s1 nz_x42 0 -0.0038465926524309064
Gnz_c1_43 0 s1 nz_x43 0 -0.0040910818234354655
Gnz_c1_44 0 s1 nz_x44 0 0.01433536088257144
Gnz_c1_45 0 s1 nz_x45 0 -0.0017716939427320187
Gnz_c1_46 0 s1 nz_x46 0 0.002336039401633238
Gnz_c1_47 0 s1 nz_x47 0 0.09696263542351735
Gnz_c1_48 0 s1 nz_x48 0 -0.002509918066082518
Gnz_c1_49 0 s1 nz_x49 0 0.00470591905766058
Gnz_c1_50 0 s1 nz_x50 0 -0.01611781732580606
Gnz_c1_51 0 s1 nz_x51 0 0.002142788606598491
Gnz_c1_52 0 s1 nz_x52 0 -0.003148466548615313
Gnz_c1_53 0 s1 nz_x53 0 -0.1231899847686398
Gnz_c1_54 0 s1 nz_x54 0 0.004622396487712009
Gnz_c1_55 0 s1 nz_x55 0 -0.09246561130528634
Gnz_c1_56 0 s1 nz_x56 0 -0.45045180967334253
Gnz_c1_57 0 s1 nz_x57 0 -0.023291120189267423
Gnz_c1_58 0 s1 nz_x58 0 0.010606349925818971
Gnz_c1_59 0 s1 nz_x59 0 0.06628712715178924
Gnz_c1_60 0 s1 nz_x60 0 -0.04697104763247121
Gnz_c1_61 0 s1 nz_x61 0 0.21307148098022438
Gnz_c1_62 0 s1 nz_x62 0 0.4096101253032676
Gnz_c1_63 0 s1 nz_x63 0 0.039413792677594074
Gnz_c1_64 0 s1 nz_x64 0 -0.022748397066994983
Gnz_c1_65 0 s1 nz_x65 0 -0.09526828667742726
Gnz_c1_66 0 s1 nz_x66 0 -0.06363611630464673
Gnz_c1_67 0 s1 nz_x67 0 -0.1035106508244889
Gnz_c1_68 0 s1 nz_x68 0 -0.3210654848118884
Gnz_c1_69 0 s1 nz_x69 0 -0.012135139506057479
Gnz_c1_70 0 s1 nz_x70 0 0.004841359413782526
Gnz_c1_71 0 s1 nz_x71 0 -0.08748080487827993
Gnz_c1_72 0 s1 nz_x72 0 0.07087638206152358
Gnz_c1_73 0 s1 nz_x73 0 0.0004787794221426662
Gnz_c1_74 0 s1 nz_x74 0 0.007940972340212168
Gnz_c1_75 0 s1 nz_x75 0 -0.0013551455350442262
Gnz_c1_76 0 s1 nz_x76 0 0.0023017154197244446
Gnz_c1_77 0 s1 nz_x77 0 0.09060209347186303
Gnz_c1_78 0 s1 nz_x78 0 -0.002566503338231516
Gnz_c1_79 0 s1 nz_x79 0 -0.00768573927162217
Gnz_c1_80 0 s1 nz_x80 0 0.005998563845259535
Gnz_c1_81 0 s1 nz_x81 0 0.0014650868002824872
Gnz_c1_82 0 s1 nz_x82 0 -0.0018623063352597431
Gnz_c1_83 0 s1 nz_x83 0 -0.061292527246674444
Gnz_c1_84 0 s1 nz_x84 0 0.00025436797145369984
Gnz_c1_85 0 s1 nz_x85 0 0.0026655194808540244
Gnz_c1_86 0 s1 nz_x86 0 -0.0048536105049379625
Gnz_c1_87 0 s1 nz_x87 0 -0.0019043104774875588
Gnz_c1_88 0 s1 nz_x88 0 0.0020779608501985867
Gnz_c1_89 0 s1 nz_x89 0 0.07462806265078385
Gnz_c1_90 0 s1 nz_x90 0 -0.002729012489991946
Gnz_d1_1 0 s1 nz_e1 0 0.24249489060101442
Gnz_c2_1 0 s2 nz_x1 0 0.008803190782214051
Gnz_c2_2 0 s2 nz_x2 0 -0.0021448909135856837
Gnz_c2_3 0 s2 nz_x3 0 0.004781440751975903
Gnz_c2_4 0 s2 nz_x4 0 -0.001805660067625323
Gnz_c2_5 0 s2 nz_x5 0 0.020651114463242182
Gnz_c2_6 0 s2 nz_x6 0 0.08296807912648721
Gnz_c2_7 0 s2 nz_x7 0 -0.5398693613477671
Gnz_c2_8 0 s2 nz_x8 0 0.5408663694001646
Gnz_c2_9 0 s2 nz_x9 0 -0.025977750359595042
Gnz_c2_10 0 s2 nz_x10 0 -0.0016420834967448511
Gnz_c2_11 0 s2 nz_x11 0 0.007549912619964215
Gnz_c2_12 0 s2 nz_x12 0 0.26119066699139665
Gnz_c2_13 0 s2 nz_x13 0 -0.3087732439682813
Gnz_c2_14 0 s2 nz_x14 0 0.5521404980355101
Gnz_c2_15 0 s2 nz_x15 0 -0.030457539589890583
Gnz_c2_16 0 s2 nz_x16 0 -0.030826773321093712
Gnz_c2_17 0 s2 nz_x17 0 -0.008395431825067952
Gnz_c2_18 0 s2 nz_x18 0 0.0605910245138051
Gnz_c2_19 0 s2 nz_x19 0 0.19811658636515134
Gnz_c2_20 0 s2 nz_x20 0 -0.49091658977191965
Gnz_c2_21 0 s2 nz_x21 0 0.031638783506758535
Gnz_c2_22 0 s2 nz_x22 0 0.004517301303926174
Gnz_c2_23 0 s2 nz_x23 0 0.02070259471218381
Gnz_c2_24 0 s2 nz_x24 0 0.20373450543986504
Gnz_c2_25 0 s2 nz_x25 0 0.0011886269017147384
Gnz_c2_26 0 s2 nz_x26 0 -0.3386620287119621
Gnz_c2_27 0 s2 nz_x27 0 0.012364926816876263
Gnz_c2_28 0 s2 nz_x28 0 0.026861204198863082
Gnz_c2_29 0 s2 nz_x29 0 -0.00902707323217214
Gnz_c2_30 0 s2 nz_x30 0 -0.29250074515048485
Gnz_c2_31 0 s2 nz_x31 0 -0.005189410613694784
Gnz_c2_32 0 s2 nz_x32 0 0.005485880108255367
Gnz_c2_33 0 s2 nz_x33 0 0.00013935489890226776
Gnz_c2_34 0 s2 nz_x34 0 -0.0006682695804786933
Gnz_c2_35 0 s2 nz_x35 0 -0.01847456499782532
Gnz_c2_36 0 s2 nz_x36 0 -0.006268957748823912
Gnz_c2_37 0 s2 nz_x37 0 -0.00015664694237086348
Gnz_c2_38 0 s2 nz_x38 0 0.0005303230838579015
Gnz_c2_39 0 s2 nz_x39 0 -5.753417410700396e-05
Gnz_c2_40 0 s2 nz_x40 0 0.0006104487242227684
Gnz_c2_41 0 s2 nz_x41 0 0.019156568799898372
Gnz_c2_42 0 s2 nz_x42 0 0.009179903917854924
Gnz_c2_43 0 s2 nz_x43 0 -0.006102054670849109
Gnz_c2_44 0 s2 nz_x44 0 0.00453648269002032
Gnz_c2_45 0 s2 nz_x45 0 -0.0002953031796197997
Gnz_c2_46 0 s2 nz_x46 0 0.0008829302718597789
Gnz_c2_47 0 s2 nz_x47 0 0.023368744776271422
Gnz_c2_48 0 s2 nz_x48 0 0.011797388085810158
Gnz_c2_49 0 s2 nz_x49 0 0.0029615005116444314
Gnz_c2_50 0 s2 nz_x50 0 -0.0009438918031508491
Gnz_c2_51 0 s2 nz_x51 0 0.000429457598022701
Gnz_c2_52 0 s2 nz_x52 0 -0.0010638714439073133
Gnz_c2_53 0 s2 nz_x53 0 -0.029675163842441846
Gnz_c2_54 0 s2 nz_x54 0 -0.014256618775256726
Gnz_c2_55 0 s2 nz_x55 0 -0.0803438126222014
Gnz_c2_56 0 s2 nz_x56 0 0.14289183995516375
Gnz_c2_57 0 s2 nz_x57 0 -0.012275878745632933
Gnz_c2_58 0 s2 nz_x58 0 -0.011184513204961615
Gnz_c2_59 0 s2 nz_x59 0 0.015917053398488323
Gnz_c2_60 0 s2 nz_x60 0 -0.21680644496452464
Gnz_c2_61 0 s2 nz_x61 0 -0.0670774785691637
Gnz_c2_62 0 s2 nz_x62 0 0.10962660055891595
Gnz_c2_63 0 s2 nz_x63 0 -0.0022299441602117664
Gnz_c2_64 0 s2 nz_x64 0 0.002730617524002444
Gnz_c2_65 0 s2 nz_x65 0 -0.023259300038807246
Gnz_c2_66 0 s2 nz_x66 0 -0.21957796811650698
Gnz_c2_67 0 s2 nz_x67 0 0.05781545849847988
Gnz_c2_68 0 s2 nz_x68 0 -0.23400726103369401
Gnz_c2_69 0 s2 nz_x69 0 0.016724668231682584
Gnz_c2_70 0 s2 nz_x70 0 0.00045224350125817804
Gnz_c2_71 0 s2 nz_x71 0 -0.02057857383586121
Gnz_c2_72 0 s2 nz_x72 0 0.2782861490971892
Gnz_c2_73 0 s2 nz_x73 0 -0.001640587094489211
Gnz_c2_74 0 s2 nz_x74 0 -0.0007810731343191159
Gnz_c2_75 0 s2 nz_x75 0 -0.0004828814282955237
Gnz_c2_76 0 s2 nz_x76 0 0.0008912629259739647
Gnz_c2_77 0 s2 nz_x77 0 0.021819375375764706
Gnz_c2_78 0 s2 nz_x78 0 0.010128253194470593
Gnz_c2_79 0 s2 nz_x79 0 -0.0029316648437773753
Gnz_c2_80 0 s2 nz_x80 0 0.006029912711246127
Gnz_c2_81 0 s2 nz_x81 0 0.00038222911590474467
Gnz_c2_82 0 s2 nz_x82 0 -0.0007904232026998356
Gnz_c2_83 0 s2 nz_x83 0 -0.014754413875349474
Gnz_c2_84 0 s2 nz_x84 0 -0.003746982160113604
Gnz_c2_85 0 s2 nz_x85 0 0.00778311192128909
Gnz_c2_86 0 s2 nz_x86 0 -0.010317011198637585
Gnz_c2_87 0 s2 nz_x87 0 -0.0002074274295367566
Gnz_c2_88 0 s2 nz_x88 0 0.0006084902901405784
Gnz_c2_89 0 s2 nz_x89 0 0.017969237214201184
Gnz_c2_90 0 s2 nz_x90 0 0.004020083750257663
Gnz_d2_1 0 s2 nz_e1 0 0.004568310437753557
Gnz_d2_2 0 s2 nz_e2 0 0.21347904516816188
Gnz_c3_1 0 s3 nz_x1 0 -0.006635601039994402
Gnz_c3_2 0 s3 nz_x2 0 -0.009720422891183333
Gnz_c3_3 0 s3 nz_x3 0 0.0014882891479057996
Gnz_c3_4 0 s3 nz_x4 0 0.0013761480872650739
Gnz_c3_5 0 s3 nz_x5 0 -0.02048330804026769
Gnz_c3_6 0 s3 nz_x6 0 -0.028843873936713914
Gnz_c3_7 0 s3 nz_x7 0 -0.07398014336804633
Gnz_c3_8 0 s3 nz_x8 0 0.2782535064489851
Gnz_c3_9 0 s3 nz_x9 0 -0.018182368250651802
Gnz_c3_10 0 s3 nz_x10 0 -0.018402356385016173
Gnz_c3_11 0 s3 nz_x11 0 -0.00826191857335356
Gnz_c3_12 0 s3 nz_x12 0 0.02541318402145082
Gnz_c3_13 0 s3 nz_x13 0 0.29878156107439874
Gnz_c3_14 0 s3 nz_x14 0 0.2773705802195863
Gnz_c3_15 0 s3 nz_x15 0 -0.03707257032610739
Gnz_c3_16 0 s3 nz_x16 0 -0.027348877195123494
Gnz_c3_17 0 s3 nz_x17 0 0.00701267944924016
Gnz_c3_18 0 s3 nz_x18 0 0.09550597748431171
Gnz_c3_19 0 s3 nz_x19 0 0.49557050150809856
Gnz_c3_20 0 s3 nz_x20 0 -0.35312898134661896
Gnz_c3_21 0 s3 nz_x21 0 0.00027925489969740153
Gnz_c3_22 0 s3 nz_x22 0 0.022581729239933616
Gnz_c3_23 0 s3 nz_x23 0 -0.020077767975510242
Gnz_c3_24 0 s3 nz_x24 0 -0.061707842234046885
Gnz_c3_25 0 s3 nz_x25 0 0.5987073987142024
Gnz_c3_26 0 s3 nz_x26 0 -0.2875281423644996
Gnz_c3_27 0 s3 nz_x27 0 0.01661124363322117
Gnz_c3_28 0 s3 nz_x28 0 0.021883157157813745
Gnz_c3_29 0 s3 nz_x29 0 0.00941646936670537
Gnz_c3_30 0 s3 nz_x30 0 0.031336656892442166
Gnz_c3_31 0 s3 nz_x31 0 0.004237086609656837
Gnz_c3_32 0 s3 nz_x32 0 -0.002442838208990744
Gnz_c3_33 0 s3 nz_x33 0 -0.00043767142998176655
Gnz_c3_34 0 s3 nz_x34 0 2.9435979715773696e-05
Gnz_c3_35 0 s3 nz_x35 0 0.018367327118121782
Gnz_c3_36 0 s3 nz_x36 0 0.00292400277050725
Gnz_c3_37 0 s3 nz_x37 0 -0.005106626579999119
Gnz_c3_38 0 s3 nz_x38 0 0.003236107725252139
Gnz_c3_39 0 s3 nz_x39 0 0.00038664502038966285
Gnz_c3_40 0 s3 nz_x40 0 -0.00014083020322586272
Gnz_c3_41 0 s3 nz_x41 0 -0.019037923583700666
Gnz_c3_42 0 s3 nz_x42 0 -0.002596418659817195
Gnz_c3_43 0 s3 nz_x43 0 -0.008606036672773239
Gnz_c3_44 0 s3 nz_x44 0 0.004349975316156775
Gnz_c3_45 0 s3 nz_x45 0 0.0006617191091075483
Gnz_c3_46 0 s3 nz_x46 0 -0.00042313221262250484
Gnz_c3_47 0 s3 nz_x47 0 -0.02320268839280737
Gnz_c3_48 0 s3 nz_x48 0 -0.0018067198869184105
Gnz_c3_49 0 s3 nz_x49 0 0.006576090053754539
Gnz_c3_50 0 s3 nz_x50 0 -0.0015685754256900687
Gnz_c3_51 0 s3 nz_x51 0 -0.0006906778265706756
Gnz_c3_52 0 s3 nz_x52 0 0.0007142732307532958
Gnz_c3_53 0 s3 nz_x53 0 0.029490236222915675
Gnz_c3_54 0 s3 nz_x54 0 0.0008689771800272878
Gnz_c3_55 0 s3 nz_x55 0 0.02597948088574236
Gnz_c3_56 0 s3 nz_x56 0 0.04863719186000427
Gnz_c3_57 0 s3 nz_x57 0 -0.005410275870519114
Gnz_c3_58 0 s3 nz_x58 0 -0.020421567970561053
Gnz_c3_59 0 s3 nz_x59 0 -0.015927542148204413
Gnz_c3_60 0 s3 nz_x60 0 0.06021334148654754
Gnz_c3_61 0 s3 nz_x61 0 -0.04556821284106615
Gnz_c3_62 0 s3 nz_x62 0 0.0279896795832066
Gnz_c3_63 0 s3 nz_x63 0 0.00036550116459010344
Gnz_c3_64 0 s3 nz_x64 0 -0.006402550438026547
Gnz_c3_65 0 s3 nz_x65 0 0.023057068001338093
Gnz_c3_66 0 s3 nz_x66 0 0.0488701175702633
Gnz_c3_67 0 s3 nz_x67 0 -0.12774103830605577
Gnz_c3_68 0 s3 nz_x68 0 -0.0549339109068824
Gnz_c3_69 0 s3 nz_x69 0 0.006100184199059429
Gnz_c3_70 0 s3 nz_x70 0 0.020687319071788685
Gnz_c3_71 0 s3 nz_x71 0 0.02056993830736181
Gnz_c3_72 0 s3 nz_x72 0 -0.06361317338361414
Gnz_c3_73 0 s3 nz_x73 0 -0.0013410062173098412
Gnz_c3_74 0 s3 nz_x74 0 -0.0016786424463436055
Gnz_c3_75 0 s3 nz_x75 0 0.0005733759350337478
Gnz_c3_76 0 s3 nz_x76 0 -0.0008375706507616789
Gnz_c3_77 0 s3 nz_x77 0 -0.021685178617516974
Gnz_c3_78 0 s3 nz_x78 0 0.001179988374103588
Gnz_c3_79 0 s3 nz_x79 0 -0.0015958966733464193
Gnz_c3_80 0 s3 nz_x80 0 0.003100590411860258
Gnz_c3_81 0 s3 nz_x81 0 -0.0005063944040918762
Gnz_c3_82 0 s3 nz_x82 0 0.0005214519468308494
Gnz_c3_83 0 s3 nz_x83 0 0.014668706517050076
Gnz_c3_84 0 s3 nz_x84 0 -0.0005051960174133732
Gnz_c3_85 0 s3 nz_x85 0 -0.0025412948770296767
Gnz_c3_86 0 s3 nz_x86 0 0.0019916268198801883
Gnz_c3_87 0 s3 nz_x87 0 0.0005581939155374123
Gnz_c3_88 0 s3 nz_x88 0 5.368744596431925e-05
Gnz_c3_89 0 s3 nz_x89 0 -0.0178670477537911
Gnz_c3_90 0 s3 nz_x90 0 -0.0030053426365502533
Gnz_d3_1 0 s3 nz_e1 0 0.0004090036955641214
Gnz_d3_2 0 s3 nz_e2 0 -0.009978627040572912
Gnz_d3_3 0 s3 nz_e3 0 0.16708159008161672
Gnz_c4_1 0 s4 nz_x1 0 0.0022236679875408745
Gnz_c4_2 0 s4 nz_x2 0 0.0380541597028436
Gnz_c4_3 0 s4 nz_x3 0 0.005278091181030917
Gnz_c4_4 0 s4 nz_x4 0 -0.002597500269312988
Gnz_c4_5 0 s4 nz_x5 0 0.06208627576217602
Gnz_c4_6 0 s4 nz_x6 0 0.12343741455547293
Gnz_c4_7 0 s4 nz_x7 0 0.06846393239188057
Gnz_c4_8 0 s4 nz_x8 0 -0.20976013525128234
Gnz_c4_9 0 s4 nz_x9 0 0.016044653347960864
Gnz_c4_10 0 s4 nz_x10 0 0.002289974856479568
Gnz_c4_11 0 s4 nz_x11 0 0.025435855398095494
Gnz_c4_12 0 s4 nz_x12 0 0.19898221494291737
Gnz_c4_13 0 s4 nz_x13 0 0.7147685112251285
Gnz_c4_14 0 s4 nz_x14 0 -0.2994025061616818
Gnz_c4_15 0 s4 nz_x15 0 0.00023719016681235803
Gnz_c4_16 0 s4 nz_x16 0 0.019183601578401047
Gnz_c4_17 0 s4 nz_x17 0 -0.025066804869401417
Gnz_c4_18 0 s4 nz_x18 0 -0.14369172460171842
Gnz_c4_19 0 s4 nz_x19 0 0.15721407591931635
Gnz_c4_20 0 s4 nz_x20 0 0.16532586053306023
Gnz_c4_21 0 s4 nz_x21 0 -0.012296248574163093
Gnz_c4_22 0 s4 nz_x22 0 -0.004595416261705072
Gnz_c4_23 0 s4 nz_x23 0 0.06201926215682925
Gnz_c4_24 0 s4 nz_x24 0 0.31888721956098465
Gnz_c4_25 0 s4 nz_x25 0 0.6917617178893503
Gnz_c4_26 0 s4 nz_x26 0 0.07794463593642184
Gnz_c4_27 0 s4 nz_x27 0 -0.01594127319946663
Gnz_c4_28 0 s4 nz_x28 0 -0.009668626795869335
Gnz_c4_29 0 s4 nz_x29 0 -0.026193857565034933
Gnz_c4_30 0 s4 nz_x30 0 -0.2958325473651578
Gnz_c4_31 0 s4 nz_x31 0 -0.007134579158913393
Gnz_c4_32 0 s4 nz_x32 0 -0.001417357220733661
Gnz_c4_33 0 s4 nz_x33 0 0.0009495483558272594
Gnz_c4_34 0 s4 nz_x34 0 -0.001127680329008976
Gnz_c4_35 0 s4 nz_x35 0 -0.055617031038567015
Gnz_c4_36 0 s4 nz_x36 0 -0.007950861498881369
Gnz_c4_37 0 s4 nz_x37 0 0.00420134033658003
Gnz_c4_38 0 s4 nz_x38 0 0.0008504477765178295
Gnz_c4_39 0 s4 nz_x39 0 -0.0008818073496651019
Gnz_c4_40 0 s4 nz_x40 0 0.0011676773390978943
Gnz_c4_41 0 s4 nz_x41 0 0.057639104823866624
Gnz_c4_42 0 s4 nz_x42 0 0.01137112090511161
Gnz_c4_43 0 s4 nz_x43 0 0.008280147761474222
Gnz_c4_44 0 s4 nz_x44 0 -0.0030297713346709044
Gnz_c4_45 0 s4 nz_x45 0 -0.0015472640925186763
Gnz_c4_46 0 s4 nz_x46 0 0.001532101644700127
Gnz_c4_47 0 s4 nz_x47 0 0.07028516059285757
Gnz_c4_48 0 s4 nz_x48 0 0.015307624491308193
Gnz_c4_49 0 s4 nz_x49 0 -0.007048803690082091
Gnz_c4_50 0 s4 nz_x50 0 -0.0016534884876281447
Gnz_c4_51 0 s4 nz_x51 0 0.0016612637094117237
Gnz_c4_52 0 s4 nz_x52 0 -0.002162632927267389
Gnz_c4_53 0 s4 nz_x53 0 -0.08930644172854929
Gnz_c4_54 0 s4 nz_x54 0 -0.01604533861331015
Gnz_c4_55 0 s4 nz_x55 0 -0.04131648968211015
Gnz_c4_56 0 s4 nz_x56 0 -0.07095538799536288
Gnz_c4_57 0 s4 nz_x57 0 -0.0012167904649798814
Gnz_c4_58 0 s4 nz_x58 0 0.009082193607458332
Gnz_c4_59 0 s4 nz_x59 0 0.048194807368211905
Gnz_c4_60 0 s4 nz_x60 0 -0.2973628738224121
Gnz_c4_61 0 s4 nz_x61 0 0.06831588569914397
Gnz_c4_62 0 s4 nz_x62 0 0.002112615044195762
Gnz_c4_63 0 s4 nz_x63 0 -0.0062967456070233815
Gnz_c4_64 0 s4 nz_x64 0 0.008548907466768516
Gnz_c4_65 0 s4 nz_x65 0 -0.06985884061804161
Gnz_c4_66 0 s4 nz_x66 0 -0.2853598378837375
Gnz_c4_67 0 s4 nz_x67 0 0.172635853952486
Gnz_c4_68 0 s4 nz_x68 0 -0.025739769394852008
Gnz_c4_69 0 s4 nz_x69 0 0.005492947347886558
Gnz_c4_70 0 s4 nz_x70 0 -0.020285844510971315
Gnz_c4_71 0 s4 nz_x71 0 -0.06298951310866253
Gnz_c4_72 0 s4 nz_x72 0 0.3656159414433761
Gnz_c4_73 0 s4 nz_x73 0 0.002530480118122627
Gnz_c4_74 0 s4 nz_x74 0 0.002838761388275605
Gnz_c4_75 0 s4 nz_x75 0 -0.0013726827499565412
Gnz_c4_76 0 s4 nz_x76 0 0.0019078775395834848
Gnz_c4_77 0 s4 nz_x77 0 0.06568132666819611
Gnz_c4_78 0 s4 nz_x78 0 0.010209352844558445
Gnz_c4_79 0 s4 nz_x79 0 -0.0029874452067246583
Gnz_c4_80 0 s4 nz_x80 0 -0.0039950813538248454
Gnz_c4_81 0 s4 nz_x81 0 0.0011179229872265496
Gnz_c4_82 0 s4 nz_x82 0 -0.0014958309559383702
Gnz_c4_83 0 s4 nz_x83 0 -0.044441004161688946
Gnz_c4_84 0 s4 nz_x84 0 -0.0037207308049629255
Gnz_c4_85 0 s4 nz_x85 0 0.008043823706815691
Gnz_c4_86 0 s4 nz_x86 0 8.397025097196695e-05
Gnz_c4_87 0 s4 nz_x87 0 -0.0010192631050651981
Gnz_c4_88 0 s4 nz_x88 0 0.0010249437429956188
Gnz_c4_89 0 s4 nz_x89 0 0.05410947918916536
Gnz_c4_90 0 s4 nz_x90 0 0.005170504551158725
Gnz_d4_1 0 s4 nz_e1 0 -0.011301937176142229
Gnz_d4_2 0 s4 nz_e2 0 -0.0036889229346388917
Gnz_d4_3 0 s4 nz_e3 0 -0.02743405487048774
Gnz_d4_4 0 s4 nz_e4 0 0.19632330060723704
Gnz_c5_1 0 s5 nz_x1 0 -0.02289360297924868
Gnz_c5_2 0 s5 nz_x2 0 -0.006710662140996727
Gnz_c5_3 0 s5 nz_x3 0 -0.003114006126409808
Gnz_c5_4 0 s5 nz_x4 0 0.0010369383445121417
Gnz_c5_5 0 s5 nz_x5 0 -0.040934901633570234
Gnz_c5_6 0 s5 nz_x6 0 -0.1011922333251196
Gnz_c5_7 0 s5 nz_x7 0 0.00021370369919354105
Gnz_c5_8 0 s5 nz_x8 0 -0.06815516311927337
Gnz_c5_9 0 s5 nz_x9 0 0.00731087296944885
Gnz_c5_10 0 s5 nz_x10 0 0.015882275540937626
Gnz_c5_11 0 s5 nz_x11 0 -0.01737058284980473
Gnz_c5_12 0 s5 nz_x12 0 -0.2335924512147806
Gnz_c5_13 0 s5 nz_x13 0 0.44592368771489677
Gnz_c5_14 0 s5 nz_x14 0 -0.11481866632855736
Gnz_c5_15 0 s5 nz_x15 0 0.01645365944652911
Gnz_c5_16 0 s5 nz_x16 0 0.021675383327611392
Gnz_c5_17 0 s5 nz_x17 0 0.018412661863121158
Gnz_c5_18 0 s5 nz_x18 0 0.05966635796324557
Gnz_c5_19 0 s5 nz_x19 0 0.3572220563746263
Gnz_c5_20 0 s5 nz_x20 0 0.03671367511700389
Gnz_c5_21 0 s5 nz_x21 0 -0.018586226727343506
Gnz_c5_22 0 s5 nz_x22 0 -0.011271887413099903
Gnz_c5_23 0 s5 nz_x23 0 -0.04102461147475572
Gnz_c5_24 0 s5 nz_x24 0 -0.2418979296058396
Gnz_c5_25 0 s5 nz_x25 0 0.31331076526853385
Gnz_c5_26 0 s5 nz_x26 0 0.11633842635763175
Gnz_c5_27 0 s5 nz_x27 0 -0.004496431818723719
Gnz_c5_28 0 s5 nz_x28 0 -0.0012711979812635192
Gnz_c5_29 0 s5 nz_x29 0 0.01714083929097372
Gnz_c5_30 0 s5 nz_x30 0 0.26548358189555094
Gnz_c5_31 0 s5 nz_x31 0 0.00659505200161986
Gnz_c5_32 0 s5 nz_x32 0 -0.004868804564874286
Gnz_c5_33 0 s5 nz_x33 0 -0.0008581773623230625
Gnz_c5_34 0 s5 nz_x34 0 0.0007374294920782071
Gnz_c5_35 0 s5 nz_x35 0 0.036663208465049016
Gnz_c5_36 0 s5 nz_x36 0 0.008572964518358728
Gnz_c5_37 0 s5 nz_x37 0 -0.00588661639744855
Gnz_c5_38 0 s5 nz_x38 0 0.002585360678390721
Gnz_c5_39 0 s5 nz_x39 0 0.0008342847062411762
Gnz_c5_40 0 s5 nz_x40 0 -0.0007152365837327257
Gnz_c5_41 0 s5 nz_x41 0 -0.03800759506067243
Gnz_c5_42 0 s5 nz_x42 0 -0.011155973993003315
Gnz_c5_43 0 s5 nz_x43 0 -0.0142180502041761
Gnz_c5_44 0 s5 nz_x44 0 0.007903139925687133
Gnz_c5_45 0 s5 nz_x45 0 0.0013318117618442888
Gnz_c5_46 0 s5 nz_x46 0 -0.00045639929605104844
Gnz_c5_47 0 s5 nz_x47 0 -0.04635938885709639
Gnz_c5_48 0 s5 nz_x48 0 -0.017181330299618165
Gnz_c5_49 0 s5 nz_x49 0 0.011628068479492928
Gnz_c5_50 0 s5 nz_x50 0 -0.005739087070180047
Gnz_c5_51 0 s5 nz_x51 0 -0.0013734825250207422
Gnz_c5_52 0 s5 nz_x52 0 0.0009431607038646764
Gnz_c5_53 0 s5 nz_x53 0 0.05889921278724312
Gnz_c5_54 0 s5 nz_x54 0 0.018666199626649334
Gnz_c5_55 0 s5 nz_x55 0 -0.016589136294759714
Gnz_c5_56 0 s5 nz_x56 0 0.00561092542819007
Gnz_c5_57 0 s5 nz_x57 0 0.008321583585034032
Gnz_c5_58 0 s5 nz_x58 0 0.017390833368478242
Gnz_c5_59 0 s5 nz_x59 0 -0.03176357459294629
Gnz_c5_60 0 s5 nz_x60 0 0.2353288975430912
Gnz_c5_61 0 s5 nz_x61 0 -0.02863041998932148
Gnz_c5_62 0 s5 nz_x62 0 -0.03827899904395148
Gnz_c5_63 0 s5 nz_x63 0 0.004249285476641623
Gnz_c5_64 0 s5 nz_x64 0 -0.00037640036048883284
Gnz_c5_65 0 s5 nz_x65 0 0.046084412557543766
Gnz_c5_66 0 s5 nz_x66 0 0.2380520220239564
Gnz_c5_67 0 s5 nz_x67 0 -0.1509923313547718
Gnz_c5_68 0 s5 nz_x68 0 0.07581803348128172
Gnz_c5_69 0 s5 nz_x69 0 -0.004453556658814097
Gnz_c5_70 0 s5 nz_x70 0 -0.009915704705967638
Gnz_c5_71 0 s5 nz_x71 0 0.04123685228815962
Gnz_c5_72 0 s5 nz_x72 0 -0.2991617427420357
Gnz_c5_73 0 s5 nz_x73 0 -0.005922094590395692
Gnz_c5_74 0 s5 nz_x74 0 0.004327942538663686
Gnz_c5_75 0 s5 nz_x75 0 0.0010450915093865069
Gnz_c5_76 0 s5 nz_x76 0 -0.0007260003843108719
Gnz_c5_77 0 s5 nz_x77 0 -0.04332199256744894
Gnz_c5_78 0 s5 nz_x78 0 -0.013913892914773195
Gnz_c5_79 0 s5 nz_x79 0 0.003475323996595596
Gnz_c5_80 0 s5 nz_x80 0 -0.005124185215534208
Gnz_c5_81 0 s5 nz_x81 0 -0.0008593073818029323
Gnz_c5_82 0 s5 nz_x82 0 0.0006191433439230452
Gnz_c5_83 0 s5 nz_x83 0 0.029300426448039978
Gnz_c5_84 0 s5 nz_x84 0 0.007148699581342728
Gnz_c5_85 0 s5 nz_x85 0 -0.005426166683037219
Gnz_c5_86 0 s5 nz_x86 0 0.006998803821037558
Gnz_c5_87 0 s5 nz_x87 0 0.0009193994306228565
Gnz_c5_88 0 s5 nz_x88 0 -0.000664539465490503
Gnz_c5_89 0 s5 nz_x89 0 -0.035664987324173794
Gnz_c5_90 0 s5 nz_x90 0 -0.006269749788704391
Gnz_d5_1 0 s5 nz_e1 0 0.00733136889402754
Gnz_d5_2 0 s5 nz_e2 0 0.006867233537457761
Gnz_d5_3 0 s5 nz_e3 0 0.09153144351433137
Gnz_d5_4 0 s5 nz_e4 0 0.024404527155233904
Gnz_d5_5 0 s5 nz_e5 0 0.17234415078596857
Gnz_c6_1 0 s6 nz_x1 0 6.086307413347513e-05
Gnz_c6_2 0 s6 nz_x2 0 -0.00026402792231863494
Gnz_c6_3 0 s6 nz_x3 0 0.0017882590087870086
Gnz_c6_4 0 s6 nz_x4 0 -0.0021432793218436334
Gnz_c6_5 0 s6 nz_x5 0 -0.03894737999911137
Gnz_c6_6 0 s6 nz_x6 0 0.0008479944717789712
Gnz_c6_7 0 s6 nz_x7 0 -0.0008057920211035154
Gnz_c6_8 0 s6 nz_x8 0 0.0006551298222426321
Gnz_c6_9 0 s6 nz_x9 0 0.00010205465998485161
Gnz_c6_10 0 s6 nz_x10 0 -0.0004892127042242924
Gnz_c6_11 0 s6 nz_x11 0 -0.016042909720814156
Gnz_c6_12 0 s6 nz_x12 0 -0.0007039286666410121
Gnz_c6_13 0 s6 nz_x13 0 0.0027456910483713306
Gnz_c6_14 0 s6 nz_x14 0 -0.0005787772475890592
Gnz_c6_15 0 s6 nz_x15 0 -0.0005367453583661223
Gnz_c6_16 0 s6 nz_x16 0 3.611620715617441e-05
Gnz_c6_17 0 s6 nz_x17 0 0.01620752483608227
Gnz_c6_18 0 s6 nz_x18 0 0.0007827398343636902
Gnz_c6_19 0 s6 nz_x19 0 -0.0032056529611503345
Gnz_c6_20 0 s6 nz_x20 0 -0.0003960169097202644
Gnz_c6_21 0 s6 nz_x21 0 0.0013707888331446498
Gnz_c6_22 0 s6 nz_x22 0 -0.0016279096361642813
Gnz_c6_23 0 s6 nz_x23 0 -0.03930926874955735
Gnz_c6_24 0 s6 nz_x24 0 -0.0009140905690267073
Gnz_c6_25 0 s6 nz_x25 0 0.005738032771344508
Gnz_c6_26 0 s6 nz_x26 0 -0.002888838532665751
Gnz_c6_27 0 s6 nz_x27 0 -0.0010625329772515027
Gnz_c6_28 0 s6 nz_x28 0 0.0009130576837927841
Gnz_c6_29 0 s6 nz_x29 0 0.016545219184663403
Gnz_c6_30 0 s6 nz_x30 0 0.0012053272922039385
Gnz_c6_31 0 s6 nz_x31 0 0.40445441146815975
Gnz_c6_32 0 s6 nz_x32 0 -0.13415108654155566
Gnz_c6_33 0 s6 nz_x33 0 0.030742323604732103
Gnz_c6_34 0 s6 nz_x34 0 0.020457367277421663
Gnz_c6_35 0 s6 nz_x35 0 0.034843988803058876
Gnz_c6_36 0 s6 nz_x36 0 0.0024577801532310634
Gnz_c6_37 0 s6 nz_x37 0 0.3175586651981597
Gnz_c6_38 0 s6 nz_x38 0 -0.20492561035279822
Gnz_c6_39 0 s6 nz_x39 0 -0.04028887942725849
Gnz_c6_40 0 s6 nz_x40 0 -0.01826708009270508
Gnz_c6_41 0 s6 nz_x41 0 -0.03600504246415766
Gnz_c6_42 0 s6 nz_x42 0 0.07294622007956993
Gnz_c6_43 0 s6 nz_x43 0 0.2672487264936415
Gnz_c6_44 0 s6 nz_x44 0 -0.16151773921635731
Gnz_c6_45 0 s6 nz_x45 0 -0.04702708324972606
Gnz_c6_46 0 s6 nz_x46 0 -0.02660470749233501
Gnz_c6_47 0 s6 nz_x47 0 -0.044021086935252314
Gnz_c6_48 0 s6 nz_x48 0 0.05981259572411849
Gnz_c6_49 0 s6 nz_x49 0 -0.27807119349553594
Gnz_c6_50 0 s6 nz_x50 0 0.1842660469497729
Gnz_c6_51 0 s6 nz_x51 0 0.0559161353469929
Gnz_c6_52 0 s6 nz_x52 0 0.028880119238295615
Gnz_c6_53 0 s6 nz_x53 0 0.055962455651225325
Gnz_c6_54 0 s6 nz_x54 0 -0.07296594281304242
Gnz_c6_55 0 s6 nz_x55 0 -0.007055892232344338
Gnz_c6_56 0 s6 nz_x56 0 0.0011121247350254551
Gnz_c6_57 0 s6 nz_x57 0 0.0026342229770648794
Gnz_c6_58 0 s6 nz_x58 0 -0.001562557424468632
Gnz_c6_59 0 s6 nz_x59 0 -0.030414789320224407
Gnz_c6_60 0 s6 nz_x60 0 0.0006451744799544694
Gnz_c6_61 0 s6 nz_x61 0 -0.0035858074982471995
Gnz_c6_62 0 s6 nz_x62 0 0.0025449135181768406
Gnz_c6_63 0 s6 nz_x63 0 -0.0022697270445007005
Gnz_c6_64 0 s6 nz_x64 0 0.003196235311120425
Gnz_c6_65 0 s6 nz_x65 0 0.04382481787760951
Gnz_c6_66 0 s6 nz_x66 0 -0.00042654994661196923
Gnz_c6_67 0 s6 nz_x67 0 -0.0029424402184253617
Gnz_c6_68 0 s6 nz_x68 0 0.0006259105889755346
Gnz_c6_69 0 s6 nz_x69 0 -1.834719937080785e-05
Gnz_c6_70 0 s6 nz_x70 0 0.0011872906157995525
Gnz_c6_71 0 s6 nz_x71 0 0.03979890094587598
Gnz_c6_72 0 s6 nz_x72 0 -0.0009496724445198925
Gnz_c6_73 0 s6 nz_x73 0 -0.1567573534584699
Gnz_c6_74 0 s6 nz_x74 0 0.029335905555044135
Gnz_c6_75 0 s6 nz_x75 0 -0.03842277369976211
Gnz_c6_76 0 s6 nz_x76 0 -0.021575815965524228
Gnz_c6_77 0 s6 nz_x77 0 -0.04123195916918725
Gnz_c6_78 0 s6 nz_x78 0 0.013639519228813176
Gnz_c6_79 0 s6 nz_x79 0 0.18086773513050106
Gnz_c6_80 0 s6 nz_x80 0 -0.049601617814100496
Gnz_c6_81 0 s6 nz_x81 0 0.02958300384385592
Gnz_c6_82 0 s6 nz_x82 0 0.017374924985579333
Gnz_c6_83 0 s6 nz_x83 0 0.027932447031922162
Gnz_c6_84 0 s6 nz_x84 0 -0.003945997238779533
Gnz_c6_85 0 s6 nz_x85 0 0.25203373434146453
Gnz_c6_86 0 s6 nz_x86 0 -0.20388430424716045
Gnz_c6_87 0 s6 nz_x87 0 -0.03719711964251565
Gnz_c6_88 0 s6 nz_x88 0 -0.019265303536778484
Gnz_c6_89 0 s6 nz_x89 0 -0.03399429302120283
Gnz_c6_90 0 s6 nz_x90 0 0.07539168593144031
Gnz_d6_1 0 s6 nz_e1 0 -0.00034882093470329253
Gnz_d6_2 0 s6 nz_e2 0 -0.0001328204818894762
Gnz_d6_3 0 s6 nz_e3 0 -0.0006592601636788686
Gnz_d6_4 0 s6 nz_e4 0 0.001996172504906853
Gnz_d6_5 0 s6 nz_e5 0 -0.001115443458908608
Gnz_d6_6 0 s6 nz_e6 0 0.25228398372037375
Gnz_c7_1 0 s7 nz_x1 0 -0.0009300716918746196
Gnz_c7_2 0 s7 nz_x2 0 0.0012713396019936993
Gnz_c7_3 0 s7 nz_x3 0 -0.0016024115731330347
Gnz_c7_4 0 s7 nz_x4 0 0.0020839743559659214
Gnz_c7_5 0 s7 nz_x5 0 0.03894021647901722
Gnz_c7_6 0 s7 nz_x6 0 -0.000928948037789681
Gnz_c7_7 0 s7 nz_x7 0 -2.8163680789033208e-05
Gnz_c7_8 0 s7 nz_x8 0 6.443669047324828e-05
Gnz_c7_9 0 s7 nz_x9 0 -4.0748690867349864e-05
Gnz_c7_10 0 s7 nz_x10 0 0.00043234532576682654
Gnz_c7_11 0 s7 nz_x11 0 0.01604713577991131
Gnz_c7_12 0 s7 nz_x12 0 0.0010062811936192607
Gnz_c7_13 0 s7 nz_x13 0 -0.003833545767979036
Gnz_c7_14 0 s7 nz_x14 0 0.0007803355475060864
Gnz_c7_15 0 s7 nz_x15 0 0.000458724646008496
Gnz_c7_16 0 s7 nz_x16 0 -0.00016715045720114296
Gnz_c7_17 0 s7 nz_x17 0 -0.016205450933053377
Gnz_c7_18 0 s7 nz_x18 0 -0.0006785111905698902
Gnz_c7_19 0 s7 nz_x19 0 0.0021868594014338577
Gnz_c7_20 0 s7 nz_x20 0 0.00024186271146218598
Gnz_c7_21 0 s7 nz_x21 0 -0.00123156547577595
Gnz_c7_22 0 s7 nz_x22 0 0.0016307827002224875
Gnz_c7_23 0 s7 nz_x23 0 0.03929843402393003
Gnz_c7_24 0 s7 nz_x24 0 0.0012762418415445222
Gnz_c7_25 0 s7 nz_x25 0 -0.005933484942131656
Gnz_c7_26 0 s7 nz_x26 0 0.0015614067778757547
Gnz_c7_27 0 s7 nz_x27 0 0.0009993183637274363
Gnz_c7_28 0 s7 nz_x28 0 -0.0008566888007172091
Gnz_c7_29 0 s7 nz_x29 0 -0.01654562899650225
Gnz_c7_30 0 s7 nz_x30 0 -0.0015312765366729739
Gnz_c7_31 0 s7 nz_x31 0 0.3678846925681053
Gnz_c7_32 0 s7 nz_x32 0 -0.20857337502116183
Gnz_c7_33 0 s7 nz_x33 0 -0.038976281207157834
Gnz_c7_34 0 s7 nz_x34 0 -0.01767256950811944
Gnz_c7_35 0 s7 nz_x35 0 -0.034732351203642674
Gnz_c7_36 0 s7 nz_x36 0 0.07121644852521751
Gnz_c7_37 0 s7 nz_x37 0 0.36311347572519354
Gnz_c7_38 0 s7 nz_x38 0 -0.1558461960713647
Gnz_c7_39 0 s7 nz_x39 0 0.030538576392549765
Gnz_c7_40 0 s7 nz_x40 0 0.020629758453130725
Gnz_c7_41 0 s7 nz_x41 0 0.03608885790813421
Gnz_c7_42 0 s7 nz_x42 0 0.015136423048870374
Gnz_c7_43 0 s7 nz_x43 0 -0.22083493765879808
Gnz_c7_44 0 s7 nz_x44 0 0.15014797696209195
Gnz_c7_45 0 s7 nz_x45 0 0.0454119535501099
Gnz_c7_46 0 s7 nz_x46 0 0.027566125175628557
Gnz_c7_47 0 s7 nz_x47 0 0.044053575675909375
Gnz_c7_48 0 s7 nz_x48 0 -0.05947991554942964
Gnz_c7_49 0 s7 nz_x49 0 0.11127621190313199
Gnz_c7_50 0 s7 nz_x50 0 -0.11968910526827267
Gnz_c7_51 0 s7 nz_x51 0 -0.0540809641690429
Gnz_c7_52 0 s7 nz_x52 0 -0.029797506739254433
Gnz_c7_53 0 s7 nz_x53 0 -0.05597822345066225
Gnz_c7_54 0 s7 nz_x54 0 0.05672350942764913
Gnz_c7_55 0 s7 nz_x55 0 0.009790918897547091
Gnz_c7_56 0 s7 nz_x56 0 -0.004003237281475536
Gnz_c7_57 0 s7 nz_x57 0 -0.0028860388907137524
Gnz_c7_58 0 s7 nz_x58 0 0.0010959750781406792
Gnz_c7_59 0 s7 nz_x59 0 0.030397613104101637
Gnz_c7_60 0 s7 nz_x60 0 -0.0005259277020871781
Gnz_c7_61 0 s7 nz_x61 0 0.00031912609482604495
Gnz_c7_62 0 s7 nz_x62 0 -0.001212958533846086
Gnz_c7_63 0 s7 nz_x63 0 0.0025442817267510754
Gnz_c7_64 0 s7 nz_x64 0 -0.0031316714154265876
Gnz_c7_65 0 s7 nz_x65 0 -0.04381229343744932
Gnz_c7_66 0 s7 nz_x66 0 -8.868801541993596e-05
Gnz_c7_67 0 s7 nz_x67 0 -0.00033067644518426013
Gnz_c7_68 0 s7 nz_x68 0 -0.0007382685710772337
Gnz_c7_69 0 s7 nz_x69 0 0.00018421985697743634
Gnz_c7_70 0 s7 nz_x70 0 -0.0008923861777105841
Gnz_c7_71 0 s7 nz_x71 0 -0.03978471573466596
Gnz_c7_72 0 s7 nz_x72 0 0.0013309093332481462
Gnz_c7_73 0 s7 nz_x73 0 -0.007595720979393936
Gnz_c7_74 0 s7 nz_x74 0 0.04543124385549246
Gnz_c7_75 0 s7 nz_x75 0 0.040007359490396945
Gnz_c7_76 0 s7 nz_x76 0 0.021195105372372586
Gnz_c7_77 0 s7 nz_x77 0 0.04115480011970325
Gnz_c7_78 0 s7 nz_x78 0 -0.033545710143132894
Gnz_c7_79 0 s7 nz_x79 0 -0.14163334060372904
Gnz_c7_80 0 s7 nz_x80 0 0.039036726311576626
Gnz_c7_81 0 s7 nz_x81 0 -0.03104519162790738
Gnz_c7_82 0 s7 nz_x82 0 -0.01736899103529035
Gnz_c7_83 0 s7 nz_x83 0 -0.027877633003896934
Gnz_c7_84 0 s7 nz_x84 0 0.004107333084035222
Gnz_c7_85 0 s7 nz_x85 0 -0.44464335101811286
Gnz_c7_86 0 s7 nz_x86 0 0.27714306274260886
Gnz_c7_87 0 s7 nz_x87 0 0.03882856836015595
Gnz_c7_88 0 s7 nz_x88 0 0.017255865514528294
Gnz_c7_89 0 s7 nz_x89 0 0.03380427557720179
Gnz_c7_90 0 s7 nz_x90 0 -0.09075776425765934
Gnz_d7_1 0 s7 nz_e1 0 0.000334323346647582
Gnz_d7_2 0 s7 nz_e2 0 -0.0001886555480585419
Gnz_d7_3 0 s7 nz_e3 0 0.0009988675014464307
Gnz_d7_4 0 s7 nz_e4 0 -0.0014611100041198707
Gnz_d7_5 0 s7 nz_e5 0 0.0013509885787765677
Gnz_d7_6 0 s7 nz_e6 0 -0.019181664002363707
Gnz_d7_7 0 s7 nz_e7 0 0.25005036316973045
Gnz_c8_1 0 s8 nz_x1 0 -0.001117403259276534
Gnz_c8_2 0 s8 nz_x2 0 0.002948796708701589
Gnz_c8_3 0 s8 nz_x3 0 -0.0029983016275531
Gnz_c8_4 0 s8 nz_x4 0 0.003953320480687222
Gnz_c8_5 0 s8 nz_x5 0 0.09298259980740772
Gnz_c8_6 0 s8 nz_x6 0 -0.0011659589595908078
Gnz_c8_7 0 s8 nz_x7 0 -0.0014533580137669787
Gnz_c8_8 0 s8 nz_x8 0 0.0009477792547027546
Gnz_c8_9 0 s8 nz_x9 0 -0.00038823176179073927
Gnz_c8_10 0 s8 nz_x10 0 0.001160824906411008
Gnz_c8_11 0 s8 nz_x11 0 0.03832717673367853
Gnz_c8_12 0 s8 nz_x12 0 0.0024875100980638882
Gnz_c8_13 0 s8 nz_x13 0 -0.008555025359156901
Gnz_c8_14 0 s8 nz_x14 0 0.0018033624984801172
Gnz_c8_15 0 s8 nz_x15 0 0.0014572489961206974
Gnz_c8_16 0 s8 nz_x16 0 -0.0009317728061512762
Gnz_c8_17 0 s8 nz_x17 0 -0.038669755689025455
Gnz_c8_18 0 s8 nz_x18 0 -0.000908343353659518
Gnz_c8_19 0 s8 nz_x19 0 0.005706322693732643
Gnz_c8_20 0 s8 nz_x20 0 -0.0014810050848563334
Gnz_c8_21 0 s8 nz_x21 0 -0.004010978704518061
Gnz_c8_22 0 s8 nz_x22 0 0.003972004546721718
Gnz_c8_23 0 s8 nz_x23 0 0.09382385894603977
Gnz_c8_24 0 s8 nz_x24 0 0.0033047025270180174
Gnz_c8_25 0 s8 nz_x25 0 -0.018976264742726234
Gnz_c8_26 0 s8 nz_x26 0 0.008204567346131064
Gnz_c8_27 0 s8 nz_x27 0 0.0029611012657498083
Gnz_c8_28 0 s8 nz_x28 0 -0.0010146734475679367
Gnz_c8_29 0 s8 nz_x29 0 -0.03951320045277524
Gnz_c8_30 0 s8 nz_x30 0 -0.004536377757165292
Gnz_c8_31 0 s8 nz_x31 0 0.40995098778340905
Gnz_c8_32 0 s8 nz_x32 0 -0.2825859111468469
Gnz_c8_33 0 s8 nz_x33 0 -0.08444963578362749
Gnz_c8_34 0 s8 nz_x34 0 -0.04777532312158388
Gnz_c8_35 0 s8 nz_x35 0 -0.08314252850237679
Gnz_c8_36 0 s8 nz_x36 0 0.11231987075350254
Gnz_c8_37 0 s8 nz_x37 0 -0.292414422283576
Gnz_c8_38 0 s8 nz_x38 0 0.258105020055781
Gnz_c8_39 0 s8 nz_x39 0 0.08429488832445886
Gnz_c8_40 0 s8 nz_x40 0 0.051169412709388885
Gnz_c8_41 0 s8 nz_x41 0 0.08625272561590258
Gnz_c8_42 0 s8 nz_x42 0 -0.11441374737527918
Gnz_c8_43 0 s8 nz_x43 0 0.11146398676289425
Gnz_c8_44 0 s8 nz_x44 0 0.10873107213579208
Gnz_c8_45 0 s8 nz_x45 0 0.09885874534847185
Gnz_c8_46 0 s8 nz_x46 0 0.07226839146741865
Gnz_c8_47 0 s8 nz_x47 0 0.10510430747162401
Gnz_c8_48 0 s8 nz_x48 0 -0.08523231710549149
Gnz_c8_49 0 s8 nz_x49 0 0.567042576089569
Gnz_c8_50 0 s8 nz_x50 0 -0.414925206673568
Gnz_c8_51 0 s8 nz_x51 0 -0.12584900361495416
Gnz_c8_52 0 s8 nz_x52 0 -0.07729532155584869
Gnz_c8_53 0 s8 nz_x53 0 -0.1335933256294648
Gnz_c8_54 0 s8 nz_x54 0 0.17212372904538792
Gnz_c8_55 0 s8 nz_x55 0 0.04043807685939588
Gnz_c8_56 0 s8 nz_x56 0 -0.02119159297527745
Gnz_c8_57 0 s8 nz_x57 0 -0.007445744392222145
Gnz_c8_58 0 s8 nz_x58 0 -0.0016531643899556853
Gnz_c8_59 0 s8 nz_x59 0 0.0725200536527722
Gnz_c8_60 0 s8 nz_x60 0 0.0013170244079963888
Gnz_c8_61 0 s8 nz_x61 0 -0.009172374680434576
Gnz_c8_62 0 s8 nz_x62 0 0.0007655016113022969
Gnz_c8_63 0 s8 nz_x63 0 0.006205616756482877
Gnz_c8_64 0 s8 nz_x64 0 -0.004893108825779122
Gnz_c8_65 0 s8 nz_x65 0 -0.10460353359303687
Gnz_c8_66 0 s8 nz_x66 0 -0.0022750860727098134
Gnz_c8_67 0 s8 nz_x67 0 -0.005752188947258469
Gnz_c8_68 0 s8 nz_x68 0 -0.0008877494073834605
Gnz_c8_69 0 s8 nz_x69 0 0.001598876508897184
Gnz_c8_70 0 s8 nz_x70 0 -0.0024773634018629307
Gnz_c8_71 0 s8 nz_x71 0 -0.09498282761910443
Gnz_c8_72 0 s8 nz_x72 0 0.0036651579768550184
Gnz_c8_73 0 s8 nz_x73 0 -0.419277014020735
Gnz_c8_74 0 s8 nz_x74 0 0.30996855113983585
Gnz_c8_75 0 s8 nz_x75 0 0.09845374882304639
Gnz_c8_76 0 s8 nz_x76 0 0.056068236763288634
Gnz_c8_77 0 s8 nz_x77 0 0.09823225506921274
Gnz_c8_78 0 s8 nz_x78 0 -0.1328654708325683
Gnz_c8_79 0 s8 nz_x79 0 0.38127917380255494
Gnz_c8_80 0 s8 nz_x80 0 -0.2550702520583052
Gnz_c8_81 0 s8 nz_x81 0 -0.08425862564213257
Gnz_c8_82 0 s8 nz_x82 0 -0.04432917972850906
Gnz_c8_83 0 s8 nz_x83 0 -0.06641769077327418
Gnz_c8_84 0 s8 nz_x84 0 0.09661308241258788
Gnz_c8_85 0 s8 nz_x85 0 -0.3171530612495089
Gnz_c8_86 0 s8 nz_x86 0 0.26171352266222436
Gnz_c8_87 0 s8 nz_x87 0 0.07883683700459633
Gnz_c8_88 0 s8 nz_x88 0 0.04666475831383884
Gnz_c8_89 0 s8 nz_x89 0 0.0809011274518638
Gnz_c8_90 0 s8 nz_x90 0 -0.10854332167929787
Gnz_d8_1 0 s8 nz_e1 0 0.0019908700077344806
Gnz_d8_2 0 s8 nz_e2 0 -0.0012758972106463621
Gnz_d8_3 0 s8 nz_e3 0 0.0006323056177502011
Gnz_d8_4 0 s8 nz_e4 0 -0.0006250799649683885
Gnz_d8_5 0 s8 nz_e5 0 0.002514300360525856
Gnz_d8_6 0 s8 nz_e6 0 0.005061963788447915
Gnz_d8_7 0 s8 nz_e7 0 -0.0024459294917949445
Gnz_d8_8 0 s8 nz_e8 0 0.27053496476161354
Gnz_c9_1 0 s9 nz_x1 0 0.0010980877174624835
Gnz_c9_2 0 s9 nz_x2 0 -0.002699048767071669
Gnz_c9_3 0 s9 nz_x3 0 0.003096827392854378
Gnz_c9_4 0 s9 nz_x4 0 -0.004550348097306149
Gnz_c9_5 0 s9 nz_x5 0 -0.09326057423118318
Gnz_c9_6 0 s9 nz_x6 0 0.0017077811146370297
Gnz_c9_7 0 s9 nz_x7 0 0.0006025050673190995
Gnz_c9_8 0 s9 nz_x8 0 -0.00016048338529458823
Gnz_c9_9 0 s9 nz_x9 0 0.00048218750733090393
Gnz_c9_10 0 s9 nz_x10 0 -0.0011944334110279109
Gnz_c9_11 0 s9 nz_x11 0 -0.03842288379169802
Gnz_c9_12 0 s9 nz_x12 0 -0.002390715426126462
Gnz_c9_13 0 s9 nz_x13 0 0.0055840473558648
Gnz_c9_14 0 s9 nz_x14 0 -0.0005291841672338891
Gnz_c9_15 0 s9 nz_x15 0 -0.0012989552993227002
Gnz_c9_16 0 s9 nz_x16 0 0.0013434777213758918
Gnz_c9_17 0 s9 nz_x17 0 0.03880045505312256
Gnz_c9_18 0 s9 nz_x18 0 0.00034731217027090676
Gnz_c9_19 0 s9 nz_x19 0 -0.004150148100313197
Gnz_c9_20 0 s9 nz_x20 0 -0.0006581217420654962
Gnz_c9_21 0 s9 nz_x21 0 0.0036779042377985223
Gnz_c9_22 0 s9 nz_x22 0 -0.004787864411321139
Gnz_c9_23 0 s9 nz_x23 0 -0.09411478054057255
Gnz_c9_24 0 s9 nz_x24 0 -0.0027549125220498105
Gnz_c9_25 0 s9 nz_x25 0 0.013257982712777944
Gnz_c9_26 0 s9 nz_x26 0 -0.004850322732480166
Gnz_c9_27 0 s9 nz_x27 0 -0.0026079721967426296
Gnz_c9_28 0 s9 nz_x28 0 0.0017907992579610037
Gnz_c9_29 0 s9 nz_x29 0 0.039631399701203225
Gnz_c9_30 0 s9 nz_x30 0 0.003919512988233043
Gnz_c9_31 0 s9 nz_x31 0 -0.36439069847921723
Gnz_c9_32 0 s9 nz_x32 0 0.2624468580816528
Gnz_c9_33 0 s9 nz_x33 0 0.08575171822755606
Gnz_c9_34 0 s9 nz_x34 0 0.044290468330182645
Gnz_c9_35 0 s9 nz_x35 0 0.08344198744972021
Gnz_c9_36 0 s9 nz_x36 0 -0.10897371752862929
Gnz_c9_37 0 s9 nz_x37 0 0.125871619044828
Gnz_c9_38 0 s9 nz_x38 0 -0.16749082718017572
Gnz_c9_39 0 s9 nz_x39 0 -0.08573060018028772
Gnz_c9_40 0 s9 nz_x40 0 -0.04723560211165479
Gnz_c9_41 0 s9 nz_x41 0 -0.08652390137908976
Gnz_c9_42 0 s9 nz_x42 0 0.0867743385258114
Gnz_c9_43 0 s9 nz_x43 0 0.4844048196066706
Gnz_c9_44 0 s9 nz_x44 0 -0.3377761955304882
Gnz_c9_45 0 s9 nz_x45 0 -0.10747506407992956
Gnz_c9_46 0 s9 nz_x46 0 -0.06601012420654626
Gnz_c9_47 0 s9 nz_x47 0 -0.10546544249000299
Gnz_c9_48 0 s9 nz_x48 0 0.13688790363488454
Gnz_c9_49 0 s9 nz_x49 0 0.06718934477088616
Gnz_c9_50 0 s9 nz_x50 0 0.1305690205597472
Gnz_c9_51 0 s9 nz_x51 0 0.12439348117987542
Gnz_c9_52 0 s9 nz_x52 0 0.07207834529551335
Gnz_c9_53 0 s9 nz_x53 0 0.13402023622972464
Gnz_c9_54 0 s9 nz_x54 0 -0.1061285719830554
Gnz_c9_55 0 s9 nz_x55 0 -0.0236016136719577
Gnz_c9_56 0 s9 nz_x56 0 0.009031341412503682
Gnz_c9_57 0 s9 nz_x57 0 0.006737634170784852
Gnz_c9_58 0 s9 nz_x58 0 -0.0024296393030063196
Gnz_c9_59 0 s9 nz_x59 0 -0.07279986009958382
Gnz_c9_60 0 s9 nz_x60 0 0.001292132596998944
Gnz_c9_61 0 s9 nz_x61 0 0.000128877883998998
Gnz_c9_62 0 s9 nz_x62 0 0.0027760669317545943
Gnz_c9_63 0 s9 nz_x63 0 -0.0052903609454264845
Gnz_c9_64 0 s9 nz_x64 0 0.006457696055395715
Gnz_c9_65 0 s9 nz_x65 0 0.10493007179284479
Gnz_c9_66 0 s9 nz_x66 0 0.001006531079342035
Gnz_c9_67 0 s9 nz_x67 0 -0.0032577101387716067
Gnz_c9_68 0 s9 nz_x68 0 0.003772582933692736
Gnz_c9_69 0 s9 nz_x69 0 -0.000992463309540581
Gnz_c9_70 0 s9 nz_x70 0 0.0034275381460080567
Gnz_c9_71 0 s9 nz_x71 0 0.09527646464105337
Gnz_c9_72 0 s9 nz_x72 0 -0.0038728158177175915
Gnz_c9_73 0 s9 nz_x73 0 0.2639116632632126
Gnz_c9_74 0 s9 nz_x74 0 -0.2317126525873603
Gnz_c9_75 0 s9 nz_x75 0 -0.100004539929241
Gnz_c9_76 0 s9 nz_x76 0 -0.051914647194061615
Gnz_c9_77 0 s9 nz_x77 0 -0.09857543441606471
Gnz_c9_78 0 s9 nz_x78 0 0.11064536859321347
Gnz_c9_79 0 s9 nz_x79 0 -0.3553692315452478
Gnz_c9_80 0 s9 nz_x80 0 0.243037454152823
Gnz_c9_81 0 s9 nz_x81 0 0.08538956317576983
Gnz_c9_82 0 s9 nz_x82 0 0.04072857338099722
Gnz_c9_83 0 s9 nz_x83 0 0.06664570066550982
Gnz_c9_84 0 s9 nz_x84 0 -0.09548501488117195
Gnz_c9_85 0 s9 nz_x85 0 0.2977018736342865
Gnz_c9_86 0 s9 nz_x86 0 -0.24937792665079192
Gnz_c9_87 0 s9 nz_x87 0 -0.07998476269176683
Gnz_c9_88 0 s9 nz_x88 0 -0.04344930388430751
Gnz_c9_89 0 s9 nz_x89 0 -0.08118494654238913
Gnz_c9_90 0 s9 nz_x90 0 0.10777469779318377
Gnz_d9_1 0 s9 nz_e1 0 -0.0013149633152667553
Gnz_d9_2 0 s9 nz_e2 0 0.0006157770954793062
Gnz_d9_3 0 s9 nz_e3 0 -0.0008246401815478596
Gnz_d9_4 0 s9 nz_e4 0 0.0013141463693793155
Gnz_d9_5 0 s9 nz_e5 0 -0.0026760462395206248
Gnz_d9_6 0 s9 nz_e6 0 -0.006403541083339006
Gnz_d9_7 0 s9 nz_e7 0 -0.034588646619573254
Gnz_d9_8 0 s9 nz_e8 0 -0.020174858340259567
Gnz_d9_9 0 s9 nz_e9 0 0.2549421400396579
Gnz_c10_1 0 s10 nz_x1 0 -0.019478539963829016
Gnz_c10_2 0 s10 nz_x2 0 -0.13575569640142307
Gnz_c10_3 0 s10 nz_x3 0 -0.015415492999405287
Gnz_c10_4 0 s10 nz_x4 0 0.007019573052578523
Gnz_c10_5 0 s10 nz_x5 0 0.1510377594885353
Gnz_c10_6 0 s10 nz_x6 0 -0.0763152979007038
Gnz_c10_7 0 s10 nz_x7 0 -0.014758613530848001
Gnz_c10_8 0 s10 nz_x8 0 0.04373685058502968
Gnz_c10_9 0 s10 nz_x9 0 -0.006311835222797145
Gnz_c10_10 0 s10 nz_x10 0 -0.005750699616704823
Gnz_c10_11 0 s10 nz_x11 0 0.06202877068985151
Gnz_c10_12 0 s10 nz_x12 0 -0.15988580274305433
Gnz_c10_13 0 s10 nz_x13 0 0.01991768515637632
Gnz_c10_14 0 s10 nz_x14 0 0.029540757981188655
Gnz_c10_15 0 s10 nz_x15 0 -0.004659801167883299
Gnz_c10_16 0 s10 nz_x16 0 -0.01758858514582213
Gnz_c10_17 0 s10 nz_x17 0 -0.0630726328234276
Gnz_c10_18 0 s10 nz_x18 0 0.10586985422191804
Gnz_c10_19 0 s10 nz_x19 0 -0.021963577689785376
Gnz_c10_20 0 s10 nz_x20 0 -0.050828146588626576
Gnz_c10_21 0 s10 nz_x21 0 -0.001233359296679666
Gnz_c10_22 0 s10 nz_x22 0 0.00920867599423526
Gnz_c10_23 0 s10 nz_x23 0 0.152865319472135
Gnz_c10_24 0 s10 nz_x24 0 -0.22453113949225803
Gnz_c10_25 0 s10 nz_x25 0 -0.01708415471205414
Gnz_c10_26 0 s10 nz_x26 0 0.008540972819164569
Gnz_c10_27 0 s10 nz_x27 0 0.007237036896568445
Gnz_c10_28 0 s10 nz_x28 0 0.015123560352809972
Gnz_c10_29 0 s10 nz_x29 0 -0.06432694238777989
Gnz_c10_30 0 s10 nz_x30 0 0.21730907917891712
Gnz_c10_31 0 s10 nz_x31 0 -0.008348141094847644
Gnz_c10_32 0 s10 nz_x32 0 0.0028512508256966075
Gnz_c10_33 0 s10 nz_x33 0 0.0018500174676503616
Gnz_c10_34 0 s10 nz_x34 0 -0.0010973028823390832
Gnz_c10_35 0 s10 nz_x35 0 -0.1364917283292197
Gnz_c10_36 0 s10 nz_x36 0 0.004237052005209124
Gnz_c10_37 0 s10 nz_x37 0 0.009999114074767059
Gnz_c10_38 0 s10 nz_x38 0 -0.010082432156882041
Gnz_c10_39 0 s10 nz_x39 0 -0.0020951018149765266
Gnz_c10_40 0 s10 nz_x40 0 0.0007955777015105417
Gnz_c10_41 0 s10 nz_x41 0 0.14141327188627836
Gnz_c10_42 0 s10 nz_x42 0 -0.0035380525208929888
Gnz_c10_43 0 s10 nz_x43 0 0.031188388911819367
Gnz_c10_44 0 s10 nz_x44 0 -0.031047774991041027
Gnz_c10_45 0 s10 nz_x45 0 -0.0029119573722721976
Gnz_c10_46 0 s10 nz_x46 0 -0.0006465026611727266
Gnz_c10_47 0 s10 nz_x47 0 0.17231266142356413
Gnz_c10_48 0 s10 nz_x48 0 0.004606130156929623
Gnz_c10_49 0 s10 nz_x49 0 -0.021308556659330288
Gnz_c10_50 0 s10 nz_x50 0 0.016254097926892086
Gnz_c10_51 0 s10 nz_x51 0 0.0030855226984831717
Gnz_c10_52 0 s10 nz_x52 0 -0.001112666275982945
Gnz_c10_53 0 s10 nz_x53 0 -0.21911101290654433
Gnz_c10_54 0 s10 nz_x54 0 0.005682518628311085
Gnz_c10_55 0 s10 nz_x55 0 0.34675558005091245
Gnz_c10_56 0 s10 nz_x56 0 0.13374190902802818
Gnz_c10_57 0 s10 nz_x57 0 -5.805250838654122e-05
Gnz_c10_58 0 s10 nz_x58 0 -0.0034338061998069355
Gnz_c10_59 0 s10 nz_x59 0 0.11826390262519844
Gnz_c10_60 0 s10 nz_x60 0 0.20243017614027126
Gnz_c10_61 0 s10 nz_x61 0 0.6161121647588386
Gnz_c10_62 0 s10 nz_x62 0 -0.18844296046363507
Gnz_c10_63 0 s10 nz_x63 0 -0.009638361334979294
Gnz_c10_64 0 s10 nz_x64 0 -0.00564803988223874
Gnz_c10_65 0 s10 nz_x65 0 -0.1700401194176725
Gnz_c10_66 0 s10 nz_x66 0 0.22867110397343793
Gnz_c10_67 0 s10 nz_x67 0 0.7272549332501539
Gnz_c10_68 0 s10 nz_x68 0 0.06294236326783664
Gnz_c10_69 0 s10 nz_x69 0 -0.0011791262433329438
Gnz_c10_70 0 s10 nz_x70 0 0.015383209086350592
Gnz_c10_71 0 s10 nz_x71 0 -0.15461744920987555
Gnz_c10_72 0 s10 nz_x72 0 -0.26029450273655785
Gnz_c10_73 0 s10 nz_x73 0 0.010333006312871824
Gnz_c10_74 0 s10 nz_x74 0 -0.007373490839991118
Gnz_c10_75 0 s10 nz_x75 0 -0.002204925878109482
Gnz_c10_76 0 s10 nz_x76 0 0.0009643212723042457
Gnz_c10_77 0 s10 nz_x77 0 0.16116418730508766
Gnz_c10_78 0 s10 nz_x78 0 -0.005218707958941512
Gnz_c10_79 0 s10 nz_x79 0 -0.006285409714830632
Gnz_c10_80 0 s10 nz_x80 0 0.00047674498068693945
Gnz_c10_81 0 s10 nz_x81 0 0.0016105438989777714
Gnz_c10_82 0 s10 nz_x82 0 -0.0009056928859132509
Gnz_c10_83 0 s10 nz_x83 0 -0.10906605024176763
Gnz_c10_84 0 s10 nz_x84 0 0.002705197462921666
Gnz_c10_85 0 s10 nz_x85 0 0.006132040204950388
Gnz_c10_86 0 s10 nz_x86 0 0.0003801832269044953
Gnz_c10_87 0 s10 nz_x87 0 -0.0016413102559917478
Gnz_c10_88 0 s10 nz_x88 0 0.0010228112109185502
Gnz_c10_89 0 s10 nz_x89 0 0.1328067412048585
Gnz_c10_90 0 s10 nz_x90 0 -0.002757037949680842
Gnz_d10_1 0 s10 nz_e1 0 0.023109851017234995
Gnz_d10_2 0 s10 nz_e2 0 0.0037349871026991998
Gnz_d10_3 0 s10 nz_e3 0 -0.026954809162441248
Gnz_d10_4 0 s10 nz_e4 0 0.06474713259148442
Gnz_d10_5 0 s10 nz_e5 0 -0.017682893596655952
Gnz_d10_6 0 s10 nz_e6 0 0.001085104388996519
Gnz_d10_7 0 s10 nz_e7 0 -0.0011006801028754967
Gnz_d10_8 0 s10 nz_e8 0 -0.0024020570206654173
Gnz_d10_9 0 s10 nz_e9 0 0.0019281665809072692
Gnz_d10_10 0 s10 nz_e10 0 0.167939170826208
Gnz_c11_1 0 s11 nz_x1 0 0.0485134957594678
Gnz_c11_2 0 s11 nz_x2 0 0.19897524809587436
Gnz_c11_3 0 s11 nz_x3 0 0.025147431101852896
Gnz_c11_4 0 s11 nz_x4 0 -0.014514571723086718
Gnz_c11_5 0 s11 nz_x5 0 -0.0843453198881387
Gnz_c11_6 0 s11 nz_x6 0 -0.0904802947257327
Gnz_c11_7 0 s11 nz_x7 0 -0.013317094603668783
Gnz_c11_8 0 s11 nz_x8 0 0.05408454364951035
Gnz_c11_9 0 s11 nz_x9 0 -0.0011054282895178523
Gnz_c11_10 0 s11 nz_x10 0 0.0013532921029729978
Gnz_c11_11 0 s11 nz_x11 0 -0.035219518924047934
Gnz_c11_12 0 s11 nz_x12 0 -0.14170793467540463
Gnz_c11_13 0 s11 nz_x13 0 -0.03775491895898925
Gnz_c11_14 0 s11 nz_x14 0 0.027398740979699233
Gnz_c11_15 0 s11 nz_x15 0 0.00030240110859703625
Gnz_c11_16 0 s11 nz_x16 0 -0.005317137421037808
Gnz_c11_17 0 s11 nz_x17 0 0.035477461550250826
Gnz_c11_18 0 s11 nz_x18 0 0.0751967557537332
Gnz_c11_19 0 s11 nz_x19 0 0.03925290328947065
Gnz_c11_20 0 s11 nz_x20 0 0.00243631982115086
Gnz_c11_21 0 s11 nz_x21 0 -0.006155635448510378
Gnz_c11_22 0 s11 nz_x22 0 0.008354015085826854
Gnz_c11_23 0 s11 nz_x23 0 -0.08609667600994692
Gnz_c11_24 0 s11 nz_x24 0 -0.18855980174449422
Gnz_c11_25 0 s11 nz_x25 0 -0.03185331212226655
Gnz_c11_26 0 s11 nz_x26 0 -0.0938421872514489
Gnz_c11_27 0 s11 nz_x27 0 0.003562188617109591
Gnz_c11_28 0 s11 nz_x28 0 -0.0003157018363319144
Gnz_c11_29 0 s11 nz_x29 0 0.03626384995232938
Gnz_c11_30 0 s11 nz_x30 0 0.1923731559846549
Gnz_c11_31 0 s11 nz_x31 0 -0.004585964285876083
Gnz_c11_32 0 s11 nz_x32 0 0.010515816033790745
Gnz_c11_33 0 s11 nz_x33 0 -0.0015366635969053294
Gnz_c11_34 0 s11 nz_x34 0 0.002164132521987902
Gnz_c11_35 0 s11 nz_x35 0 0.0764184019236369
Gnz_c11_36 0 s11 nz_x36 0 -0.0024523569568947142
Gnz_c11_37 0 s11 nz_x37 0 0.00035249491923970043
Gnz_c11_38 0 s11 nz_x38 0 -0.004924416519418155
Gnz_c11_39 0 s11 nz_x39 0 0.0017805877262042143
Gnz_c11_40 0 s11 nz_x40 0 -0.0021917474735797474
Gnz_c11_41 0 s11 nz_x41 0 -0.07919594915201059
Gnz_c11_42 0 s11 nz_x42 0 -0.0005218165173790675
Gnz_c11_43 0 s11 nz_x43 0 -0.007646678515062293
Gnz_c11_44 0 s11 nz_x44 0 0.0018084836932170958
Gnz_c11_45 0 s11 nz_x45 0 0.0023396856279691036
Gnz_c11_46 0 s11 nz_x46 0 -0.0018447077174505806
Gnz_c11_47 0 s11 nz_x47 0 -0.09657433323661681
Gnz_c11_48 0 s11 nz_x48 0 -0.006963740732710252
Gnz_c11_49 0 s11 nz_x49 0 0.00012554401266486628
Gnz_c11_50 0 s11 nz_x50 0 0.00805330996906585
Gnz_c11_51 0 s11 nz_x51 0 -0.0023355317281316926
Gnz_c11_52 0 s11 nz_x52 0 0.0028509271358876853
Gnz_c11_53 0 s11 nz_x53 0 0.12271281359118634
Gnz_c11_54 0 s11 nz_x54 0 0.003873613653618116
Gnz_c11_55 0 s11 nz_x55 0 0.6659014860630245
Gnz_c11_56 0 s11 nz_x56 0 -0.30373824153078294
Gnz_c11_57 0 s11 nz_x57 0 -0.009291419360708274
Gnz_c11_58 0 s11 nz_x58 0 -0.0054446849042036
Gnz_c11_59 0 s11 nz_x59 0 -0.06607051439424334
Gnz_c11_60 0 s11 nz_x60 0 0.20011485082012398
Gnz_c11_61 0 s11 nz_x61 0 0.513958048161095
Gnz_c11_62 0 s11 nz_x62 0 0.1537536893656036
Gnz_c11_63 0 s11 nz_x63 0 -0.005240242062200586
Gnz_c11_64 0 s11 nz_x64 0 0.01662868844041933
Gnz_c11_65 0 s11 nz_x65 0 0.09492349286729442
Gnz_c11_66 0 s11 nz_x66 0 0.1440311357983197
Gnz_c11_67 0 s11 nz_x67 0 0.8146032829057396
Gnz_c11_68 0 s11 nz_x68 0 -0.2580245522178353
Gnz_c11_69 0 s11 nz_x69 0 -0.020003484016586616
Gnz_c11_70 0 s11 nz_x70 0 0.002232199059432975
Gnz_c11_71 0 s11 nz_x71 0 0.08707326362183207
Gnz_c11_72 0 s11 nz_x72 0 -0.2018311497585573
Gnz_c11_73 0 s11 nz_x73 0 0.001288343986632619
Gnz_c11_74 0 s11 nz_x74 0 -0.007543661337813066
Gnz_c11_75 0 s11 nz_x75 0 0.00146255282922203
Gnz_c11_76 0 s11 nz_x76 0 -0.0020345910851047888
Gnz_c11_77 0 s11 nz_x77 0 -0.09025320097743882
Gnz_c11_78 0 s11 nz_x78 0 -0.003594420204476485
Gnz_c11_79 0 s11 nz_x79 0 -0.003599493617021502
Gnz_c11_80 0 s11 nz_x80 0 0.00993954249205957
Gnz_c11_81 0 s11 nz_x81 0 -0.001041298557524342
Gnz_c11_82 0 s11 nz_x82 0 0.001701304428348333
Gnz_c11_83 0 s11 nz_x83 0 0.061066113996932285
Gnz_c11_84 0 s11 nz_x84 0 -0.00027493540040248257
Gnz_c11_85 0 s11 nz_x85 0 0.005274314421928107
Gnz_c11_86 0 s11 nz_x86 0 -0.012648220643986349
Gnz_c11_87 0 s11 nz_x87 0 0.0014066787294645317
Gnz_c11_88 0 s11 nz_x88 0 -0.001938275586521334
Gnz_c11_89 0 s11 nz_x89 0 -0.07434685692750992
Gnz_c11_90 0 s11 nz_x90 0 0.004405270776674733
Gnz_d11_1 0 s11 nz_e1 0 -0.04814903804654643
Gnz_d11_2 0 s11 nz_e2 0 -0.0007861239454736736
Gnz_d11_3 0 s11 nz_e3 0 0.009394043203904235
Gnz_d11_4 0 s11 nz_e4 0 0.0015714139652015045
Gnz_d11_5 0 s11 nz_e5 0 0.003288147062373842
Gnz_d11_6 0 s11 nz_e6 0 -1.3913627538227266e-05
Gnz_d11_7 0 s11 nz_e7 0 0.0003150516089627198
Gnz_d11_8 0 s11 nz_e8 0 0.0012106304719246993
Gnz_d11_9 0 s11 nz_e9 0 -0.0008780122454175
Gnz_d11_10 0 s11 nz_e10 0 0.0201317509782877
Gnz_d11_11 0 s11 nz_e11 0 0.1466045408741223
Gnz_c12_1 0 s12 nz_x1 0 -0.01714764004553975
Gnz_c12_2 0 s12 nz_x2 0 -0.07879418193901086
Gnz_c12_3 0 s12 nz_x3 0 -0.006482766874586764
Gnz_c12_4 0 s12 nz_x4 0 0.002586563579883202
Gnz_c12_5 0 s12 nz_x5 0 -0.06743326515862098
Gnz_c12_6 0 s12 nz_x6 0 0.14040442388331859
Gnz_c12_7 0 s12 nz_x7 0 0.008351850911661317
Gnz_c12_8 0 s12 nz_x8 0 -0.058326296625025816
Gnz_c12_9 0 s12 nz_x9 0 0.006940945313702309
Gnz_c12_10 0 s12 nz_x10 0 0.00018739186997874914
Gnz_c12_11 0 s12 nz_x11 0 -0.027130065301058673
Gnz_c12_12 0 s12 nz_x12 0 0.25022235393131054
Gnz_c12_13 0 s12 nz_x13 0 -0.07701922166670477
Gnz_c12_14 0 s12 nz_x14 0 -0.02716766588229157
Gnz_c12_15 0 s12 nz_x15 0 0.004241486562582432
Gnz_c12_16 0 s12 nz_x16 0 0.014383029220008474
Gnz_c12_17 0 s12 nz_x17 0 0.027556901899750474
Gnz_c12_18 0 s12 nz_x18 0 -0.13637277034190515
Gnz_c12_19 0 s12 nz_x19 0 0.07216125604556657
Gnz_c12_20 0 s12 nz_x20 0 -0.01501307787273514
Gnz_c12_21 0 s12 nz_x21 0 0.004495992661774635
Gnz_c12_22 0 s12 nz_x22 0 -0.01660003497749686
Gnz_c12_23 0 s12 nz_x23 0 -0.06758993066330184
Gnz_c12_24 0 s12 nz_x24 0 0.33659729412336975
Gnz_c12_25 0 s12 nz_x25 0 -0.12223187072251482
Gnz_c12_26 0 s12 nz_x26 0 0.09391074832058662
Gnz_c12_27 0 s12 nz_x27 0 -0.0031245724993561427
Gnz_c12_28 0 s12 nz_x28 0 -0.006957951244867454
Gnz_c12_29 0 s12 nz_x29 0 0.028252325532898977
Gnz_c12_30 0 s12 nz_x30 0 -0.33682780546616364
Gnz_c12_31 0 s12 nz_x31 0 -0.0027377932171774766
Gnz_c12_32 0 s12 nz_x32 0 0.0013069226764445814
Gnz_c12_33 0 s12 nz_x33 0 -1.0395724008691066e-05
Gnz_c12_34 0 s12 nz_x34 0 0.0006731334705907667
Gnz_c12_35 0 s12 nz_x35 0 0.06042235786285601
Gnz_c12_36 0 s12 nz_x36 0 -0.007605194350112317
Gnz_c12_37 0 s12 nz_x37 0 -0.00026541289146328993
Gnz_c12_38 0 s12 nz_x38 0 -0.0015144165760879297
Gnz_c12_39 0 s12 nz_x39 0 0.00010796522356172683
Gnz_c12_40 0 s12 nz_x40 0 -0.000522975940292127
Gnz_c12_41 0 s12 nz_x41 0 -0.06261408267628807
Gnz_c12_42 0 s12 nz_x42 0 0.010917302911015432
Gnz_c12_43 0 s12 nz_x43 0 -0.0034885610444349608
Gnz_c12_44 0 s12 nz_x44 0 -0.0010593073488700346
Gnz_c12_45 0 s12 nz_x45 0 0.0005047037152868998
Gnz_c12_46 0 s12 nz_x46 0 -0.00078204851140418
Gnz_c12_47 0 s12 nz_x47 0 -0.07635003413993972
Gnz_c12_48 0 s12 nz_x48 0 0.01562951614391025
Gnz_c12_49 0 s12 nz_x49 0 -0.0023127389672639056
Gnz_c12_50 0 s12 nz_x50 0 0.005528766700137785
Gnz_c12_51 0 s12 nz_x51 0 -0.000366866973076014
Gnz_c12_52 0 s12 nz_x52 0 0.001266946272270732
Gnz_c12_53 0 s12 nz_x53 0 0.09701175183650541
Gnz_c12_54 0 s12 nz_x54 0 -0.020765949053426443
Gnz_c12_55 0 s12 nz_x55 0 0.5718918321713217
Gnz_c12_56 0 s12 nz_x56 0 0.051256492247504795
Gnz_c12_57 0 s12 nz_x57 0 -0.0009513843807161476
Gnz_c12_58 0 s12 nz_x58 0 0.012417455326344508
Gnz_c12_59 0 s12 nz_x59 0 -0.05230745086375785
Gnz_c12_60 0 s12 nz_x60 0 -0.3173671515922616
Gnz_c12_61 0 s12 nz_x61 0 0.5926823803097044
Gnz_c12_62 0 s12 nz_x62 0 -0.13035546173559256
Gnz_c12_63 0 s12 nz_x63 0 -0.016748035390655943
Gnz_c12_64 0 s12 nz_x64 0 0.0018698596376716104
Gnz_c12_65 0 s12 nz_x65 0 0.0758112378880644
Gnz_c12_66 0 s12 nz_x66 0 -0.28120126618871777
Gnz_c12_67 0 s12 nz_x67 0 0.765532287539945
Gnz_c12_68 0 s12 nz_x68 0 0.004836063781676776
Gnz_c12_69 0 s12 nz_x69 0 -0.0015309037113346684
Gnz_c12_70 0 s12 nz_x70 0 0.006533594754350042
Gnz_c12_71 0 s12 nz_x71 0 0.06838439755999506
Gnz_c12_72 0 s12 nz_x72 0 0.3768442026491419
Gnz_c12_73 0 s12 nz_x73 0 0.0035147287189611375
Gnz_c12_74 0 s12 nz_x74 0 -0.0053029949104463495
Gnz_c12_75 0 s12 nz_x75 0 0.000328386430698586
Gnz_c12_76 0 s12 nz_x76 0 -0.0012780324328020192
Gnz_c12_77 0 s12 nz_x77 0 -0.07134723868427924
Gnz_c12_78 0 s12 nz_x78 0 0.01704525753511081
Gnz_c12_79 0 s12 nz_x79 0 -0.005822298786061346
Gnz_c12_80 0 s12 nz_x80 0 0.003698007139909944
Gnz_c12_81 0 s12 nz_x81 0 -0.00016350749402139995
Gnz_c12_82 0 s12 nz_x82 0 0.0011711729519303625
Gnz_c12_83 0 s12 nz_x83 0 0.04827885797251345
Gnz_c12_84 0 s12 nz_x84 0 -0.008372615470127819
Gnz_c12_85 0 s12 nz_x85 0 0.0029039589997732805
Gnz_c12_86 0 s12 nz_x86 0 0.00045801490888053466
Gnz_c12_87 0 s12 nz_x87 0 5.8339498324960837e-05
Gnz_c12_88 0 s12 nz_x88 0 -0.0006365237790289187
Gnz_c12_89 0 s12 nz_x89 0 -0.058786276015600096
Gnz_c12_90 0 s12 nz_x90 0 0.003717255140038587
Gnz_d12_1 0 s12 nz_e1 0 0.016250714233205177
Gnz_d12_2 0 s12 nz_e2 0 -0.004588421027634644
Gnz_d12_3 0 s12 nz_e3 0 0.03744100619221137
Gnz_d12_4 0 s12 nz_e4 0 -0.028432204177057843
Gnz_d12_5 0 s12 nz_e5 0 0.03490451111055001
Gnz_d12_6 0 s12 nz_e6 0 0.000560145293831362
Gnz_d12_7 0 s12 nz_e7 0 -3.164366374564078e-05
Gnz_d12_8 0 s12 nz_e8 0 0.0006388475377067759
Gnz_d12_9 0 s12 nz_e9 0 2.415724653304633e-06
Gnz_d12_10 0 s12 nz_e10 0 0.09985609101164616
Gnz_d12_11 0 s12 nz_e11 0 0.08895671495573057
Gnz_d12_12 0 s12 nz_e12 0 0.06850329988229467
Gnz_c13_1 0 s13 nz_x1 0 0.00011230141694739257
Gnz_c13_2 0 s13 nz_x2 0 0.0011393771445096256
Gnz_c13_3 0 s13 nz_x3 0 -0.0014934658272182852
Gnz_c13_4 0 s13 nz_x4 0 0.0025366713534304103
Gnz_c13_5 0 s13 nz_x5 0 0.05441737718937781
Gnz_c13_6 0 s13 nz_x6 0 -0.0007402501489212479
Gnz_c13_7 0 s13 nz_x7 0 -0.00033556535022041426
Gnz_c13_8 0 s13 nz_x8 0 -0.00011383988542876349
Gnz_c13_9 0 s13 nz_x9 0 -0.00041342506956701966
Gnz_c13_10 0 s13 nz_x10 0 0.0007630429986300402
Gnz_c13_11 0 s13 nz_x11 0 0.022413817437982403
Gnz_c13_12 0 s13 nz_x12 0 0.001325927389478836
Gnz_c13_13 0 s13 nz_x13 0 -0.001144665087204819
Gnz_c13_14 0 s13 nz_x14 0 -0.0004855029855001028
Gnz_c13_15 0 s13 nz_x15 0 0.000822291289938659
Gnz_c13_16 0 s13 nz_x16 0 -0.0012012873550163762
Gnz_c13_17 0 s13 nz_x17 0 -0.02263592641707641
Gnz_c13_18 0 s13 nz_x18 0 0.0003683790514782564
Gnz_c13_19 0 s13 nz_x19 0 0.0014980001070108151
Gnz_c13_20 0 s13 nz_x20 0 0.0009680219662513853
Gnz_c13_21 0 s13 nz_x21 0 -0.0023174100732411417
Gnz_c13_22 0 s13 nz_x22 0 0.003220847126155136
Gnz_c13_23 0 s13 nz_x23 0 0.05491533649202097
Gnz_c13_24 0 s13 nz_x24 0 0.001368482461430032
Gnz_c13_25 0 s13 nz_x25 0 -0.006788269149347619
Gnz_c13_26 0 s13 nz_x26 0 0.003133823800467787
Gnz_c13_27 0 s13 nz_x27 0 0.001513198824392928
Gnz_c13_28 0 s13 nz_x28 0 -0.0010511973318080054
Gnz_c13_29 0 s13 nz_x29 0 -0.02312677306312307
Gnz_c13_30 0 s13 nz_x30 0 -0.0022808379212416
Gnz_c13_31 0 s13 nz_x31 0 -0.20651959479969637
Gnz_c13_32 0 s13 nz_x32 0 0.03579955102531634
Gnz_c13_33 0 s13 nz_x33 0 -0.04493280942928576
Gnz_c13_34 0 s13 nz_x34 0 -0.025231497309140302
Gnz_c13_35 0 s13 nz_x35 0 -0.04877513473226925
Gnz_c13_36 0 s13 nz_x36 0 0.015902757105247193
Gnz_c13_37 0 s13 nz_x37 0 -0.008638249224968619
Gnz_c13_38 0 s13 nz_x38 0 0.05447336025487631
Gnz_c13_39 0 s13 nz_x39 0 0.048361327207364684
Gnz_c13_40 0 s13 nz_x40 0 0.025620873165662687
Gnz_c13_41 0 s13 nz_x41 0 0.05046778417025215
Gnz_c13_42 0 s13 nz_x42 0 -0.04006285274763689
Gnz_c13_43 0 s13 nz_x43 0 -0.3600954177118803
Gnz_c13_44 0 s13 nz_x44 0 0.2162060352045889
Gnz_c13_45 0 s13 nz_x45 0 0.06411472498408681
Gnz_c13_46 0 s13 nz_x46 0 0.036512510729659886
Gnz_c13_47 0 s13 nz_x47 0 0.061525648562537755
Gnz_c13_48 0 s13 nz_x48 0 -0.08249152476858206
Gnz_c13_49 0 s13 nz_x49 0 0.26532781523458904
Gnz_c13_50 0 s13 nz_x50 0 -0.19853706907380111
Gnz_c13_51 0 s13 nz_x51 0 -0.07625832134520126
Gnz_c13_52 0 s13 nz_x52 0 -0.039587492041942035
Gnz_c13_53 0 s13 nz_x53 0 -0.0782069620450896
Gnz_c13_54 0 s13 nz_x54 0 0.08637891213228786
Gnz_c13_55 0 s13 nz_x55 0 0.011506327943094167
Gnz_c13_56 0 s13 nz_x56 0 -0.003510301745052867
Gnz_c13_57 0 s13 nz_x57 0 -0.0036715359465422036
Gnz_c13_58 0 s13 nz_x58 0 0.001605799169480472
Gnz_c13_59 0 s13 nz_x59 0 0.04248264790870433
Gnz_c13_60 0 s13 nz_x60 0 -0.0009264470459020403
Gnz_c13_61 0 s13 nz_x61 0 0.0013269216021161545
Gnz_c13_62 0 s13 nz_x62 0 -0.0022279293761644117
Gnz_c13_63 0 s13 nz_x63 0 0.002526261334177615
Gnz_c13_64 0 s13 nz_x64 0 -0.003514111366377951
Gnz_c13_65 0 s13 nz_x65 0 -0.06122789831840338
Gnz_c13_66 0 s13 nz_x66 0 -0.0007292206611470655
Gnz_c13_67 0 s13 nz_x67 0 0.0049769511850631725
Gnz_c13_68 0 s13 nz_x68 0 -0.0031002202348480406
Gnz_c13_69 0 s13 nz_x69 0 0.000677410363290403
Gnz_c13_70 0 s13 nz_x70 0 -0.002636388614456467
Gnz_c13_71 0 s13 nz_x71 0 -0.05559236362102166
Gnz_c13_72 0 s13 nz_x72 0 0.0024816827456513703
Gnz_c13_73 0 s13 nz_x73 0 0.17319303946353826
Gnz_c13_74 0 s13 nz_x74 0 -0.025190644873708704
Gnz_c13_75 0 s13 nz_x75 0 0.05611521419490883
Gnz_c13_76 0 s13 nz_x76 0 0.03016716287672764
Gnz_c13_77 0 s13 nz_x77 0 0.05748880275471481
Gnz_c13_78 0 s13 nz_x78 0 -0.031218331972380463
Gnz_c13_79 0 s13 nz_x79 0 0.42170762659819
Gnz_c13_80 0 s13 nz_x80 0 -0.26329699309136484
Gnz_c13_81 0 s13 nz_x81 0 -0.05500096234736491
Gnz_c13_82 0 s13 nz_x82 0 -0.02274492834091907
Gnz_c13_83 0 s13 nz_x83 0 -0.03884349372575453
Gnz_c13_84 0 s13 nz_x84 0 0.08892878612350366
Gnz_c13_85 0 s13 nz_x85 0 0.18049475905370765
Gnz_c13_86 0 s13 nz_x86 0 -0.04683283583571538
Gnz_c13_87 0 s13 nz_x87 0 0.04079503064921547
Gnz_c13_88 0 s13 nz_x88 0 0.024657375785731413
Gnz_c13_89 0 s13 nz_x89 0 0.04746144017555457
Gnz_c13_90 0 s13 nz_x90 0 -0.010313796911943158
Gnz_d13_1 0 s13 nz_e1 0 0.0010244647684195594
Gnz_d13_2 0 s13 nz_e2 0 -0.0004423396491747025
Gnz_d13_3 0 s13 nz_e3 0 -0.0004030297209042914
Gnz_d13_4 0 s13 nz_e4 0 -0.0002400602422875956
Gnz_d13_5 0 s13 nz_e5 0 0.0011058827599696667
Gnz_d13_6 0 s13 nz_e6 0 -0.010156392818342816
Gnz_d13_7 0 s13 nz_e7 0 -0.03369674504668416
Gnz_d13_8 0 s13 nz_e8 0 -0.0005271733903617978
Gnz_d13_9 0 s13 nz_e9 0 -0.04429585794147015
Gnz_d13_10 0 s13 nz_e10 0 -0.001174265506747992
Gnz_d13_11 0 s13 nz_e11 0 0.0007232601114117971
Gnz_d13_12 0 s13 nz_e12 0 -0.00011149761554626646
Gnz_d13_13 0 s13 nz_e13 0 0.2534915317002656
Gnz_c14_1 0 s14 nz_x1 0 -0.002427537812518204
Gnz_c14_2 0 s14 nz_x2 0 0.0011534406956846103
Gnz_c14_3 0 s14 nz_x3 0 0.001967024961290371
Gnz_c14_4 0 s14 nz_x4 0 -0.0025003140903147552
Gnz_c14_5 0 s14 nz_x5 0 -0.05444191265177685
Gnz_c14_6 0 s14 nz_x6 0 0.00010344192529372985
Gnz_c14_7 0 s14 nz_x7 0 -0.0008074925844045638
Gnz_c14_8 0 s14 nz_x8 0 0.0011776364566443752
Gnz_c14_9 0 s14 nz_x9 0 0.0003987105910301641
Gnz_c14_10 0 s14 nz_x10 0 -0.0008243839626284926
Gnz_c14_11 0 s14 nz_x11 0 -0.02241413251124798
Gnz_c14_12 0 s14 nz_x12 0 -0.0006917726002011342
Gnz_c14_13 0 s14 nz_x13 0 -0.0018344543996129988
Gnz_c14_14 0 s14 nz_x14 0 0.0012014871081300943
Gnz_c14_15 0 s14 nz_x15 0 -0.0008847480374474565
Gnz_c14_16 0 s14 nz_x16 0 0.0009110372924721756
Gnz_c14_17 0 s14 nz_x17 0 0.022644021137023206
Gnz_c14_18 0 s14 nz_x18 0 -0.0002223460634850618
Gnz_c14_19 0 s14 nz_x19 0 -0.0023809129242328875
Gnz_c14_20 0 s14 nz_x20 0 -0.0018259782730202165
Gnz_c14_21 0 s14 nz_x21 0 0.0022991844903160245
Gnz_c14_22 0 s14 nz_x22 0 -0.0030764481520802853
Gnz_c14_23 0 s14 nz_x23 0 -0.05494928907886953
Gnz_c14_24 0 s14 nz_x24 0 -0.0007032919791608431
Gnz_c14_25 0 s14 nz_x25 0 0.005363430300060919
Gnz_c14_26 0 s14 nz_x26 0 -0.004972330641904845
Gnz_c14_27 0 s14 nz_x27 0 -0.001515680317427232
Gnz_c14_28 0 s14 nz_x28 0 0.0010921356180286048
Gnz_c14_29 0 s14 nz_x29 0 0.02313167172140673
Gnz_c14_30 0 s14 nz_x30 0 0.0016525335367561893
Gnz_c14_31 0 s14 nz_x31 0 0.3208310339861082
Gnz_c14_32 0 s14 nz_x32 0 -0.08112081903878003
Gnz_c14_33 0 s14 nz_x33 0 0.04214571656174026
Gnz_c14_34 0 s14 nz_x34 0 0.024753285262356053
Gnz_c14_35 0 s14 nz_x35 0 0.04886524123194772
Gnz_c14_36 0 s14 nz_x36 0 -0.006487929812844245
Gnz_c14_37 0 s14 nz_x37 0 -0.21686844993999901
Gnz_c14_38 0 s14 nz_x38 0 0.06272798495715581
Gnz_c14_39 0 s14 nz_x39 0 -0.04571819206963732
Gnz_c14_40 0 s14 nz_x40 0 -0.025577920687184112
Gnz_c14_41 0 s14 nz_x41 0 -0.050556392717271824
Gnz_c14_42 0 s14 nz_x42 0 0.006916661115217675
Gnz_c14_43 0 s14 nz_x43 0 0.4409007138136939
Gnz_c14_44 0 s14 nz_x44 0 -0.2384314724971662
Gnz_c14_45 0 s14 nz_x45 0 -0.06684592855702821
Gnz_c14_46 0 s14 nz_x46 0 -0.03516831816771755
Gnz_c14_47 0 s14 nz_x47 0 -0.061519438222880904
Gnz_c14_48 0 s14 nz_x48 0 0.08458915770381013
Gnz_c14_49 0 s14 nz_x49 0 -0.48104532739782846
Gnz_c14_50 0 s14 nz_x50 0 0.2790737783643291
Gnz_c14_51 0 s14 nz_x51 0 0.07932487326603889
Gnz_c14_52 0 s14 nz_x52 0 0.037835758177792
Gnz_c14_53 0 s14 nz_x53 0 0.07819433422805518
Gnz_c14_54 0 s14 nz_x54 0 -0.10512081808524397
Gnz_c14_55 0 s14 nz_x55 0 -0.009423773775973369
Gnz_c14_56 0 s14 nz_x56 0 0.00030415384541799195
Gnz_c14_57 0 s14 nz_x57 0 0.003267032994794324
Gnz_c14_58 0 s14 nz_x58 0 -0.001837235547031199
Gnz_c14_59 0 s14 nz_x59 0 -0.04251665526748791
Gnz_c14_60 0 s14 nz_x60 0 0.0006772090659663868
Gnz_c14_61 0 s14 nz_x61 0 -0.004993085460529927
Gnz_c14_62 0 s14 nz_x62 0 0.00393434874876125
Gnz_c14_63 0 s14 nz_x63 0 -0.0021911976572430974
Gnz_c14_64 0 s14 nz_x64 0 0.003579939135129889
Gnz_c14_65 0 s14 nz_x65 0 0.06126515034129747
Gnz_c14_66 0 s14 nz_x66 0 -7.862604201887318e-05
Gnz_c14_67 0 s14 nz_x67 0 -0.011100789747042008
Gnz_c14_68 0 s14 nz_x68 0 0.0028973372403804363
Gnz_c14_69 0 s14 nz_x69 0 -0.0004109532169394105
Gnz_c14_70 0 s14 nz_x70 0 0.002943325870523948
Gnz_c14_71 0 s14 nz_x71 0 0.05563158555354889
Gnz_c14_72 0 s14 nz_x72 0 -0.0017190423580967814
Gnz_c14_73 0 s14 nz_x73 0 0.5677963358982565
Gnz_c14_74 0 s14 nz_x74 0 -0.3528570491503316
Gnz_c14_75 0 s14 nz_x75 0 -0.06700478823605713
Gnz_c14_76 0 s14 nz_x76 0 -0.027708930961650984
Gnz_c14_77 0 s14 nz_x77 0 -0.05744401258555882
Gnz_c14_78 0 s14 nz_x78 0 0.1254069601569719
Gnz_c14_79 0 s14 nz_x79 0 0.23737162871744033
Gnz_c14_80 0 s14 nz_x80 0 -0.013048002977998373
Gnz_c14_81 0 s14 nz_x81 0 0.047964034498823166
Gnz_c14_82 0 s14 nz_x82 0 0.026573996125187772
Gnz_c14_83 0 s14 nz_x83 0 0.03902827655560005
Gnz_c14_84 0 s14 nz_x84 0 -0.03222846558417607
Gnz_c14_85 0 s14 nz_x85 0 -0.2454699353141305
Gnz_c14_86 0 s14 nz_x86 0 0.07856628615105563
Gnz_c14_87 0 s14 nz_x87 0 -0.03802961297316384
Gnz_c14_88 0 s14 nz_x88 0 -0.024080551855890336
Gnz_c14_89 0 s14 nz_x89 0 -0.04753992213651272
Gnz_c14_90 0 s14 nz_x90 0 0.004844493696645615
Gnz_d14_1 0 s14 nz_e1 0 -0.001814093847632408
Gnz_d14_2 0 s14 nz_e2 0 0.0003144597308615783
Gnz_d14_3 0 s14 nz_e3 0 0.0010270282527857506
Gnz_d14_4 0 s14 nz_e4 0 0.0009156016911688884
Gnz_d14_5 0 s14 nz_e5 0 -0.0005236753394557667
Gnz_d14_6 0 s14 nz_e6 0 0.00741047573850723
Gnz_d14_7 0 s14 nz_e7 0 -0.006544138320594318
Gnz_d14_8 0 s14 nz_e8 0 0.004137094549289063
Gnz_d14_9 0 s14 nz_e9 0 -0.003853985086437481
Gnz_d14_10 0 s14 nz_e10 0 0.0012080445251554627
Gnz_d14_11 0 s14 nz_e11 0 -0.00015306549143655402
Gnz_d14_12 0 s14 nz_e12 0 0.001741573705126801
Gnz_d14_13 0 s14 nz_e13 0 -0.010252122076251192
Gnz_d14_14 0 s14 nz_e14 0 0.27812354511191995
Gnz_c15_1 0 s15 nz_x1 0 0.0006280347264325303
Gnz_c15_2 0 s15 nz_x2 0 -0.0006365209043544226
Gnz_c15_3 0 s15 nz_x3 0 -0.0019089451743424864
Gnz_c15_4 0 s15 nz_x4 0 0.002083100591164143
Gnz_c15_5 0 s15 nz_x5 0 0.03888558574323494
Gnz_c15_6 0 s15 nz_x6 0 -0.0007168398867464545
Gnz_c15_7 0 s15 nz_x7 0 0.0015992160587836063
Gnz_c15_8 0 s15 nz_x8 0 -0.0013742666847334857
Gnz_c15_9 0 s15 nz_x9 0 -0.0001615504921973645
Gnz_c15_10 0 s15 nz_x10 0 0.0004738726741082575
Gnz_c15_11 0 s15 nz_x11 0 0.01601364703209429
Gnz_c15_12 0 s15 nz_x12 0 0.00047926606730687774
Gnz_c15_13 0 s15 nz_x13 0 -0.00217934065992954
Gnz_c15_14 0 s15 nz_x14 0 0.000526409615885633
Gnz_c15_15 0 s15 nz_x15 0 0.0007281439396748537
Gnz_c15_16 0 s15 nz_x16 0 7.004342016194405e-05
Gnz_c15_17 0 s15 nz_x17 0 -0.016179874395339477
Gnz_c15_18 0 s15 nz_x18 0 -0.0008542391030039812
Gnz_c15_19 0 s15 nz_x19 0 0.004782658455570575
Gnz_c15_20 0 s15 nz_x20 0 2.6269617641296965e-05
Gnz_c15_21 0 s15 nz_x21 0 -0.0015651530844616242
Gnz_c15_22 0 s15 nz_x22 0 0.001573934874089637
Gnz_c15_23 0 s15 nz_x23 0 0.03924751856129075
Gnz_c15_24 0 s15 nz_x24 0 0.0006311197725207693
Gnz_c15_25 0 s15 nz_x25 0 -0.006247540275653596
Gnz_c15_26 0 s15 nz_x26 0 0.004632322907842472
Gnz_c15_27 0 s15 nz_x27 0 0.0012108056986757088
Gnz_c15_28 0 s15 nz_x28 0 -0.0008752338871766375
Gnz_c15_29 0 s15 nz_x29 0 -0.016517175023447028
Gnz_c15_30 0 s15 nz_x30 0 -0.000935943673850477
Gnz_c15_31 0 s15 nz_x31 0 0.333533272354712
Gnz_c15_32 0 s15 nz_x32 0 -0.22743492822765274
Gnz_c15_33 0 s15 nz_x33 0 -0.03956763212769973
Gnz_c15_34 0 s15 nz_x34 0 -0.020492488266139926
Gnz_c15_35 0 s15 nz_x35 0 -0.034886518638757545
Gnz_c15_36 0 s15 nz_x36 0 0.08004597015117904
Gnz_c15_37 0 s15 nz_x37 0 -0.5079346532363088
Gnz_c15_38 0 s15 nz_x38 0 0.3037563479750688
Gnz_c15_39 0 s15 nz_x39 0 0.042693349974523134
Gnz_c15_40 0 s15 nz_x40 0 0.018973865109381458
Gnz_c15_41 0 s15 nz_x41 0 0.035962715259627104
Gnz_c15_42 0 s15 nz_x42 0 -0.0987069629753455
Gnz_c15_43 0 s15 nz_x43 0 -0.27361141152010554
Gnz_c15_44 0 s15 nz_x44 0 0.16686750263725225
Gnz_c15_45 0 s15 nz_x45 0 0.04669922334025475
Gnz_c15_46 0 s15 nz_x46 0 0.02764200964115528
Gnz_c15_47 0 s15 nz_x47 0 0.04395859791991129
Gnz_c15_48 0 s15 nz_x48 0 -0.06137064298204643
Gnz_c15_49 0 s15 nz_x49 0 0.3006453921479784
Gnz_c15_50 0 s15 nz_x50 0 -0.19531930342994624
Gnz_c15_51 0 s15 nz_x51 0 -0.05547916070484082
Gnz_c15_52 0 s15 nz_x52 0 -0.030137492654710864
Gnz_c15_53 0 s15 nz_x53 0 -0.055877794600608585
Gnz_c15_54 0 s15 nz_x54 0 0.07662152005661976
Gnz_c15_55 0 s15 nz_x55 0 0.006859151889032697
Gnz_c15_56 0 s15 nz_x56 0 0.00016534417031865132
Gnz_c15_57 0 s15 nz_x57 0 -0.002485893142941497
Gnz_c15_58 0 s15 nz_x58 0 0.0015490677874814055
Gnz_c15_59 0 s15 nz_x59 0 0.03037038131138016
Gnz_c15_60 0 s15 nz_x60 0 -0.0004456601740298803
Gnz_c15_61 0 s15 nz_x61 0 0.005458645020738167
Gnz_c15_62 0 s15 nz_x62 0 -0.003415033897618559
Gnz_c15_63 0 s15 nz_x63 0 0.0022101640591533776
Gnz_c15_64 0 s15 nz_x64 0 -0.003045456647415481
Gnz_c15_65 0 s15 nz_x65 0 -0.043755884588898966
Gnz_c15_66 0 s15 nz_x66 0 0.0008138344424060008
Gnz_c15_67 0 s15 nz_x67 0 0.00413071832891021
Gnz_c15_68 0 s15 nz_x68 0 0.00024469412074952355
Gnz_c15_69 0 s15 nz_x69 0 0.00010953331826750581
Gnz_c15_70 0 s15 nz_x70 0 -0.0011945196240190034
Gnz_c15_71 0 s15 nz_x71 0 -0.039737544885753116
Gnz_c15_72 0 s15 nz_x72 0 0.0004928864465347377
Gnz_c15_73 0 s15 nz_x73 0 0.18130625445972828
Gnz_c15_74 0 s15 nz_x74 0 -0.04280983280351965
Gnz_c15_75 0 s15 nz_x75 0 0.03710754089095431
Gnz_c15_76 0 s15 nz_x76 0 0.022428635561421995
Gnz_c15_77 0 s15 nz_x77 0 0.041174467634208754
Gnz_c15_78 0 s15 nz_x78 0 -0.009392499081612075
Gnz_c15_79 0 s15 nz_x79 0 -0.18313282405449452
Gnz_c15_80 0 s15 nz_x80 0 0.053589972320765504
Gnz_c15_81 0 s15 nz_x81 0 -0.028394953624829238
Gnz_c15_82 0 s15 nz_x82 0 -0.017979654116293466
Gnz_c15_83 0 s15 nz_x83 0 -0.027888110440102785
Gnz_c15_84 0 s15 nz_x84 0 0.003127872003884433
Gnz_c15_85 0 s15 nz_x85 0 0.4262585933125407
Gnz_c15_86 0 s15 nz_x86 0 -0.1395772306088685
Gnz_c15_87 0 s15 nz_x87 0 0.029271034500001576
Gnz_c15_88 0 s15 nz_x88 0 0.021706220810202678
Gnz_c15_89 0 s15 nz_x89 0 0.03388645702634538
Gnz_c15_90 0 s15 nz_x90 0 0.0013982466886243558
Gnz_d15_1 0 s15 nz_e1 0 0.0002997819822772069
Gnz_d15_2 0 s15 nz_e2 0 0.0005491522231924431
Gnz_d15_3 0 s15 nz_e3 0 0.00045231712452057553
Gnz_d15_4 0 s15 nz_e4 0 -0.0022468975180715577
Gnz_d15_5 0 s15 nz_e5 0 0.0009790915352466787
Gnz_d15_6 0 s15 nz_e6 0 -0.020438814353984574
Gnz_d15_7 0 s15 nz_e7 0 -0.01887253675285207
Gnz_d15_8 0 s15 nz_e8 0 -0.0021645622025466744
Gnz_d15_9 0 s15 nz_e9 0 0.0007555564532124879
Gnz_d15_10 0 s15 nz_e10 0 -0.0016487904005803306
Gnz_d15_11 0 s15 nz_e11 0 0.00015044685936080744
Gnz_d15_12 0 s15 nz_e12 0 -0.0003539930795096047
Gnz_d15_13 0 s15 nz_e13 0 0.004475668117447519
Gnz_d15_14 0 s15 nz_e14 0 -0.003114153820544704
Gnz_d15_15 0 s15 nz_e15 0 0.2658628398502538
Gdcp_v1 0 dcp_d1 p1 0 1e-06
Rdcp_1 dcp_d1 0 1.0 noisy=0
Cdcp_1 dcp_d1 0 0.0009947183943243459
Gdcp_v2 0 dcp_d2 p2 0 1e-06
Rdcp_2 dcp_d2 0 1.0 noisy=0
Cdcp_2 dcp_d2 0 0.0009947183943243459
Gdcp_v3 0 dcp_d3 p3 0 1e-06
Rdcp_3 dcp_d3 0 1.0 noisy=0
Cdcp_3 dcp_d3 0 0.0009947183943243459
Gdcp_v4 0 dcp_d4 p4 0 1e-06
Rdcp_4 dcp_d4 0 1.0 noisy=0
Cdcp_4 dcp_d4 0 0.0009947183943243459
Gdcp_v5 0 dcp_d5 p5 0 1e-06
Rdcp_5 dcp_d5 0 1.0 noisy=0
Cdcp_5 dcp_d5 0 0.0009947183943243459
Gdcp_v6 0 dcp_d6 p6 0 1e-06
Rdcp_6 dcp_d6 0 1.0 noisy=0
Cdcp_6 dcp_d6 0 0.0009947183943243459
Gdcp_v7 0 dcp_d7 p7 0 1e-06
Rdcp_7 dcp_d7 0 1.0 noisy=0
Cdcp_7 dcp_d7 0 0.0009947183943243459
Gdcp_v8 0 dcp_d8 p8 0 1e-06
Rdcp_8 dcp_d8 0 1.0 noisy=0
Cdcp_8 dcp_d8 0 0.0009947183943243459
Gdcp_v9 0 dcp_d9 p9 0 1e-06
Rdcp_9 dcp_d9 0 1.0 noisy=0
Cdcp_9 dcp_d9 0 0.0009947183943243459
Gdcp_v10 0 dcp_d10 p10 0 1e-06
Rdcp_10 dcp_d10 0 1.0 noisy=0
Cdcp_10 dcp_d10 0 0.0009947183943243459
Gdcp_v11 0 dcp_d11 p11 0 1e-06
Rdcp_11 dcp_d11 0 1.0 noisy=0
Cdcp_11 dcp_d11 0 0.0009947183943243459
Gdcp_v12 0 dcp_d12 p12 0 1e-06
Rdcp_12 dcp_d12 0 1.0 noisy=0
Cdcp_12 dcp_d12 0 0.0009947183943243459
Gdcp_v13 0 dcp_d13 p13 0 1e-06
Rdcp_13 dcp_d13 0 1.0 noisy=0
Cdcp_13 dcp_d13 0 0.0009947183943243459
Gdcp_v14 0 dcp_d14 p14 0 1e-06
Rdcp_14 dcp_d14 0 1.0 noisy=0
Cdcp_14 dcp_d14 0 0.0009947183943243459
Gdcp_v15 0 dcp_d15 p15 0 1e-06
Rdcp_15 dcp_d15 0 1.0 noisy=0
Cdcp_15 dcp_d15 0 0.0009947183943243459
Gdcp_y1_1 p1 0 dcp_d1 0 13816.302149815108
Gdcp_y1_2 p1 0 dcp_d2 0 -18744.174828415424
Gdcp_y1_3 p1 0 dcp_d3 0 18771.14150716222
Gdcp_y1_4 p1 0 dcp_d4 0 -14310.14297331501
Gdcp_y1_5 p1 0 dcp_d5 0 -4449.173621129344
Gdcp_y1_6 p1 0 dcp_d6 0 -305.0354272687919
Gdcp_y1_7 p1 0 dcp_d7 0 305.6193877924718
Gdcp_y1_8 p1 0 dcp_d8 0 372.5881683623658
Gdcp_y1_9 p1 0 dcp_d9 0 -371.71623978575485
Gdcp_y1_10 p1 0 dcp_d10 0 -469.66050078108003
Gdcp_y1_11 p1 0 dcp_d11 0 -13792.5154805435
Gdcp_y1_12 p1 0 dcp_d12 0 14290.733359602958
Gdcp_y1_13 p1 0 dcp_d13 0 66.14261464376898
Gdcp_y1_14 p1 0 dcp_d14 0 -65.2693330629086
Gdcp_y1_15 p1 0 dcp_d15 0 304.81652609273823
Gdcp_y2_1 p2 0 dcp_d1 0 -18744.2125903316
Gdcp_y2_2 p2 0 dcp_d2 0 25745.54141684926
Gdcp_y2_3 p2 0 dcp_d3 0 -25493.02435530221
Gdcp_y2_4 p2 0 dcp_d4 0 19142.363678897294
Gdcp_y2_5 p2 0 dcp_d5 0 6375.882786853748
Gdcp_y2_6 p2 0 dcp_d6 0 283.94498133578645
Gdcp_y2_7 p2 0 dcp_d7 0 -283.3600827706548
Gdcp_y2_8 p2 0 dcp_d8 0 -489.36331732932734
Gdcp_y2_9 p2 0 dcp_d9 0 490.5358277503668
Gdcp_y2_10 p2 0 dcp_d10 0 478.61950336590587
Gdcp_y2_11 p2 0 dcp_d11 0 18735.531568721846
Gdcp_y2_12 p2 0 dcp_d12 0 -19197.374940507136
Gdcp_y2_13 p2 0 dcp_d13 0 -207.4280192623586
Gdcp_y2_14 p2 0 dcp_d14 0 208.17297538698384
Gdcp_y2_15 p2 0 dcp_d15 0 -284.80118148757094
Gdcp_y3_1 p3 0 dcp_d1 0 18771.17501798703
Gdcp_y3_2 p3 0 dcp_d2 0 -25493.00974874047
Gdcp_y3_3 p3 0 dcp_d3 0 25223.426711413977
Gdcp_y3_4 p3 0 dcp_d4 0 -19173.794490404824
Gdcp_y3_5 p3 0 dcp_d5 0 -6074.698946276436
Gdcp_y3_6 p3 0 dcp_d6 0 -289.9750133775296
Gdcp_y3_7 p3 0 dcp_d7 0 289.42853948353036
Gdcp_y3_8 p3 0 dcp_d8 0 497.29157692474973
Gdcp_y3_9 p3 0 dcp_d9 0 -498.16357323991156
Gdcp_y3_10 p3 0 dcp_d10 0 -487.7722051182688
Gdcp_y3_11 p3 0 dcp_d11 0 -18762.67137633947
Gdcp_y3_12 p3 0 dcp_d12 0 19234.424433954708
Gdcp_y3_13 p3 0 dcp_d13 0 208.97423288410548
Gdcp_y3_14 p3 0 dcp_d14 0 -209.69827251136107
Gdcp_y3_15 p3 0 dcp_d15 0 290.8204530793022
Gdcp_y4_1 p4 0 dcp_d1 0 -14310.145137985342
Gdcp_y4_2 p4 0 dcp_d2 0 19142.32385977971
Gdcp_y4_3 p4 0 dcp_d3 0 -19173.758777064537
Gdcp_y4_4 p4 0 dcp_d4 0 15108.604720338482
Gdcp_y4_5 p4 0 dcp_d5 0 4052.5665974350813
Gdcp_y4_6 p4 0 dcp_d6 0 589.9561604065275
Gdcp_y4_7 p4 0 dcp_d7 0 -589.5637727371221
Gdcp_y4_8 p4 0 dcp_d8 0 -724.3522784995821
Gdcp_y4_9 p4 0 dcp_d9 0 724.4934500479708
Gdcp_y4_10 p4 0 dcp_d10 0 817.8337130152272
Gdcp_y4_11 p4 0 dcp_d11 0 14283.206478387323
Gdcp_y4_12 p4 0 dcp_d12 0 -15087.390355985164
Gdcp_y4_13 p4 0 dcp_d13 0 -134.65403406892966
Gdcp_y4_14 p4 0 dcp_d14 0 134.62703975252248
Gdcp_y4_15 p4 0 dcp_d15 0 -590.129965688642
Gdcp_y5_1 p5 0 dcp_d1 0 -4449.214265221102
Gdcp_y5_2 p5 0 dcp_d2 0 6375.901482469803
Gdcp_y5_3 p5 0 dcp_d3 0 -6074.728492881932
Gdcp_y5_4 p5 0 dcp_d4 0 4052.611642168025
Gdcp_y5_5 p5 0 dcp_d5 0 2022.9305835473
Gdcp_y5_6 p5 0 dcp_d6 0 -299.9586287729637
Gdcp_y5_7 p5 0 dcp_d7 0 300.29102365169285
Gdcp_y5_8 p5 0 dcp_d8 0 227.54468530973918
Gdcp_y5_9 p5 0 dcp_d9 0 -226.58171084184028
Gdcp_y5_10 p5 0 dcp_d10 0 -329.24903735074423
Gdcp_y5_11 p5 0 dcp_d11 0 4467.621191144744
Gdcp_y5_12 p5 0 dcp_d12 0 -4133.907470342868
Gdcp_y5_13 p5 0 dcp_d13 0 -74.25359069122058
Gdcp_y5_14 p5 0 dcp_d14 0 75.24000884843747
Gdcp_y5_15 p5 0 dcp_d15 0 299.2661376867607
Gdcp_y6_1 p6 0 dcp_d1 0 -305.0352003084386
Gdcp_y6_2 p6 0 dcp_d2 0 283.9479640533351
Gdcp_y6_3 p6 0 dcp_d3 0 -289.97775263632684
Gdcp_y6_4 p6 0 dcp_d4 0 589.9558965859233
Gdcp_y6_5 p6 0 dcp_d5 0 -299.95549378753276
Gdcp_y6_6 p6 0 dcp_d6 0 263.60852884887987
Gdcp_y6_7 p6 0 dcp_d7 0 -266.0621548662423
Gdcp_y6_8 p6 0 dcp_d8 0 -280.80330262124363
Gdcp_y6_9 p6 0 dcp_d9 0 276.9990836869948
Gdcp_y6_10 p6 0 dcp_d10 0 279.36823564028714
Gdcp_y6_11 p6 0 dcp_d11 0 305.4808382624112
Gdcp_y6_12 p6 0 dcp_d12 0 -585.5364436209848
Gdcp_y6_13 p6 0 dcp_d13 0 -9.434451092943386
Gdcp_y6_14 p6 0 dcp_d14 0 3.292942918439734
Gdcp_y6_15 p6 0 dcp_d15 0 -265.0105035840733
Gdcp_y7_1 p7 0 dcp_d1 0 305.6191825134211
Gdcp_y7_2 p7 0 dcp_d2 0 -283.36294473833846
Gdcp_y7_3 p7 0 dcp_d3 0 289.43119207849867
Gdcp_y7_4 p7 0 dcp_d4 0 -589.5636357162518
Gdcp_y7_5 p7 0 dcp_d5 0 300.2881265322423
Gdcp_y7_6 p7 0 dcp_d6 0 -266.0623167446974
Gdcp_y7_7 p7 0 dcp_d7 0 264.9114053263346
Gdcp_y7_8 p7 0 dcp_d8 0 279.67859139022
Gdcp_y7_9 p7 0 dcp_d9 0 -277.2237521989629
Gdcp_y7_10 p7 0 dcp_d10 0 -278.4360767619995
Gdcp_y7_11 p7 0 dcp_d11 0 -306.0679337891677
Gdcp_y7_12 p7 0 dcp_d12 0 585.2154918591681
Gdcp_y7_13 p7 0 dcp_d13 0 9.77669165731776
Gdcp_y7_14 p7 0 dcp_d14 0 -4.823624514371794
Gdcp_y7_15 p7 0 dcp_d15 0 266.3471304957255
Gdcp_y8_1 p8 0 dcp_d1 0 372.58777551401477
Gdcp_y8_2 p8 0 dcp_d2 0 -489.367315380752
Gdcp_y8_3 p8 0 dcp_d3 0 497.29541019057774
Gdcp_y8_4 p8 0 dcp_d4 0 -724.3515816470828
Gdcp_y8_5 p8 0 dcp_d5 0 227.54008675627063
Gdcp_y8_6 p8 0 dcp_d6 0 -280.80307266165755
Gdcp_y8_7 p8 0 dcp_d7 0 279.67821411575835
Gdcp_y8_8 p8 0 dcp_d8 0 345.9115774202409
Gdcp_y8_9 p8 0 dcp_d9 0 -345.9207088338523
Gdcp_y8_10 p8 0 dcp_d10 0 -346.8515901682984
Gdcp_y8_11 p8 0 dcp_d11 0 -373.20442915299986
Gdcp_y8_12 p8 0 dcp_d12 0 718.9400254620851
Gdcp_y8_13 p8 0 dcp_d13 0 65.82851497452005
Gdcp_y8_14 p8 0 dcp_d14 0 -67.07137233936781
Gdcp_y8_15 p8 0 dcp_d15 0 281.17786886738827
Gdcp_y9_1 p9 0 dcp_d1 0 -371.71606542409086
Gdcp_y9_2 p9 0 dcp_d2 0 490.5399626647673
Gdcp_y9_3 p9 0 dcp_d3 0 -498.1675101974198
Gdcp_y9_4 p9 0 dcp_d4 0 724.4932847553648
Gdcp_y9_5 p9 0 dcp_d5 0 -226.57749085298886
Gdcp_y9_6 p9 0 dcp_d6 0 276.99918941579557
Gdcp_y9_7 p9 0 dcp_d7 0 -277.2237265317792
Gdcp_y9_8 p9 0 dcp_d8 0 -345.9210083298775
Gdcp_y9_9 p9 0 dcp_d9 0 342.48760457770976
Gdcp_y9_10 p9 0 dcp_d10 0 345.866537096895
Gdcp_y9_11 p9 0 dcp_d11 0 372.4565722620435
Gdcp_y9_12 p9 0 dcp_d12 0 -719.082645251154
Gdcp_y9_13 p9 0 dcp_d13 0 -65.90413351329275
Gdcp_y9_14 p9 0 dcp_d14 0 65.88486543568709
Gdcp_y9_15 p9 0 dcp_d15 0 -277.0974372694676
Gdcp_y10_1 p10 0 dcp_d1 0 -469.66089903928423
Gdcp_y10_2 p10 0 dcp_d2 0 478.6287569199591
Gdcp_y10_3 p10 0 dcp_d3 0 -487.7812191391856
Gdcp_y10_4 p10 0 dcp_d4 0 817.8339572532182
Gdcp_y10_5 p10 0 dcp_d5 0 -329.24001244713855
Gdcp_y10_6 p10 0 dcp_d6 0 279.3681556696945
Gdcp_y10_7 p10 0 dcp_d7 0 -278.43588053338283
Gdcp_y10_8 p10 0 dcp_d8 0 -346.8516907446234
Gdcp_y10_9 p10 0 dcp_d9 0 345.866361844277
Gdcp_y10_10 p10 0 dcp_d10 0 345.34078613063235
Gdcp_y10_11 p10 0 dcp_d11 0 470.0560190321612
Gdcp_y10_12 p10 0 dcp_d12 0 -812.124243759628
Gdcp_y10_13 p10 0 dcp_d13 0 -67.00681954307717
Gdcp_y10_14 p10 0 dcp_d14 0 68.01675212373023
Gdcp_y10_15 p10 0 dcp_d15 0 -279.7156124331943
Gdcp_y11_1 p11 0 dcp_d1 0 -13792.513788837836
Gdcp_y11_2 p11 0 dcp_d2 0 18735.497881732288
Gdcp_y11_3 p11 0 dcp_d3 0 -18762.64191251359
Gdcp_y11_4 p11 0 dcp_d4 0 14283.202537068719
Gdcp_y11_5 p11 0 dcp_d5 0 4467.586285031744
Gdcp_y11_6 p11 0 dcp_d6 0 305.4810651656019
Gdcp_y11_7 p11 0 dcp_d7 0 -306.06811212931933
Gdcp_y11_8 p11 0 dcp_d8 0 -373.2048410392958
Gdcp_y11_9 p11 0 dcp_d9 0 372.4567308639945
Gdcp_y11_10 p11 0 dcp_d10 0 470.0556435535061
Gdcp_y11_11 p11 0 dcp_d11 0 13766.579351945918
Gdcp_y11_12 p11 0 dcp_d12 0 -14263.824006072402
Gdcp_y11_13 p11 0 dcp_d13 0 -66.43941530252388
Gdcp_y11_14 p11 0 dcp_d14 0 65.56773135758809
Gdcp_y11_15 p11 0 dcp_d15 0 -305.2711188038099
Gdcp_y12_1 p12 0 dcp_d1 0 14290.731906411393
Gdcp_y12_2 p12 0 dcp_d2 0 -19197.339240109413
Gdcp_y12_3 p12 0 dcp_d3 0 19234.392766513065
Gdcp_y12_4 p12 0 dcp_d4 0 -15087.386599970887
Gdcp_y12_5 p12 0 dcp_d5 0 -4133.870232065684
Gdcp_y12_6 p12 0 dcp_d6 0 -585.5365907720262
Gdcp_y12_7 p12 0 dcp_d7 0 585.2154921410571
Gdcp_y12_8 p12 0 dcp_d8 0 718.9405491064214
Gdcp_y12_9 p12 0 dcp_d9 0 -719.0827173919681
Gdcp_y12_10 p12 0 dcp_d10 0 -812.1238750779108
Gdcp_y12_11 p12 0 dcp_d11 0 -14263.824317814478
Gdcp_y12_12 p12 0 dcp_d12 0 15061.768777052232
Gdcp_y12_13 p12 0 dcp_d13 0 133.5861333607597
Gdcp_y12_14 p12 0 dcp_d14 0 -133.5034389107117
Gdcp_y12_15 p12 0 dcp_d15 0 585.7033076711871
Gdcp_y13_1 p13 0 dcp_d1 0 66.14241402043594
Gdcp_y13_2 p13 0 dcp_d2 0 -207.42923813873387
Gdcp_y13_3 p13 0 dcp_d3 0 208.97546020753413
Gdcp_y13_4 p13 0 dcp_d4 0 -134.65388718730125
Gdcp_y13_5 p13 0 dcp_d5 0 -74.25498621509065
Gdcp_y13_6 p13 0 dcp_d6 0 -9.434461868240707
Gdcp_y13_7 p13 0 dcp_d7 0 9.776844252379346
Gdcp_y13_8 p13 0 dcp_d8 0 65.82842727016931
Gdcp_y13_9 p13 0 dcp_d9 0 -65.90429440031868
Gdcp_y13_10 p13 0 dcp_d10 0 -67.00686565434648
Gdcp_y13_11 p13 0 dcp_d11 0 -66.43921289134491
Gdcp_y13_12 p13 0 dcp_d12 0 133.5859577672304
Gdcp_y13_13 p13 0 dcp_d13 0 55.544947309957294
Gdcp_y13_14 p13 0 dcp_d14 0 -61.5167949727935
Gdcp_y13_15 p13 0 dcp_d15 0 9.330044646677083
Gdcp_y14_1 p14 0 dcp_d1 0 -65.26918488652598
Gdcp_y14_2 p14 0 dcp_d2 0 208.17452023967056
Gdcp_y14_3 p14 0 dcp_d3 0 -209.69981078942718
Gdcp_y14_4 p14 0 dcp_d4 0 134.6269308268918
Gdcp_y14_5 p14 0 dcp_d5 0 75.24166445642932
Gdcp_y14_6 p14 0 dcp_d6 0 3.2930865131591824
Gdcp_y14_7 p14 0 dcp_d7 0 -4.823818055665896
Gdcp_y14_8 p14 0 dcp_d8 0 -67.07129594933984
Gdcp_y14_9 p14 0 dcp_d9 0 65.88494710505627
Gdcp_y14_10 p14 0 dcp_d10 0 68.01679398935057
Gdcp_y14_11 p14 0 dcp_d11 0 65.56758913719291
Gdcp_y14_12 p14 0 dcp_d12 0 -133.50330706621457
Gdcp_y14_13 p14 0 dcp_d13 0 -61.51673626096643
Gdcp_y14_14 p14 0 dcp_d14 0 62.350881405118244
Gdcp_y14_15 p14 0 dcp_d15 0 -2.9117980827192413
Gdcp_y15_1 p15 0 dcp_d1 0 304.8164961444236
Gdcp_y15_2 p15 0 dcp_d2 0 -284.80398207108954
Gdcp_y15_3 p15 0 dcp_d3 0 290.8230281418074
Gdcp_y15_4 p15 0 dcp_d4 0 -590.1297423121649
Gdcp_y15_5 p15 0 dcp_d5 0 299.26324966046695
Gdcp_y15_6 p15 0 dcp_d6 0 -265.01029283876323
Gdcp_y15_7 p15 0 dcp_d7 0 266.3466716783247
Gdcp_y15_8 p15 0 dcp_d8 0 281.1781131833793
Gdcp_y15_9 p15 0 dcp_d9 0 -277.097081237368
Gdcp_y15_10 p15 0 dcp_d10 0 -279.71558880371396
Gdcp_y15_11 p15 0 dcp_d11 0 -305.27110008699356
Gdcp_y15_12 p15 0 dcp_d12 0 585.7032215783389
Gdcp_y15_13 p15 0 dcp_d13 0 9.330073865290723
Gdcp_y15_14 p15 0 dcp_d14 0 -2.9118127736760258
Gdcp_y15_15 p15 0 dcp_d15 0 263.52556635550474
.ENDS cascode_em_dc_ngspice_le
